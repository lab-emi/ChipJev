* NGSPICE file created from layout.ext - technology: sky130A

.subckt layout inn inp o1 out s1t s2ld t1 vdd vss x1
X0 o1.t7 inn.t2 t1.t8 vdd.t14 sky130_fd_pr__pfet_01v8 ad=14.0737 pd=97.64 as=14.0737 ps=97.64 w=48.53 l=2.4
X1 out.t11 o1.t12 sky130_fd_pr__cap_mim_m3_1 l=29.96 w=29.96
X2 o1.t8 inn.t1 t1.t7 vdd.t15 sky130_fd_pr__pfet_01v8 ad=14.0737 pd=97.64 as=14.0737 ps=97.64 w=48.53 l=2.4
X3 x1.t9 inp.t1 t1.t10 vdd.t26 sky130_fd_pr__pfet_01v8 ad=14.0737 pd=97.64 as=14.0737 ps=97.64 w=48.53 l=2.4
X4 x1.t10 inp.t0 t1.t11 vdd.t27 sky130_fd_pr__pfet_01v8 ad=14.0737 pd=97.64 as=14.0737 ps=97.64 w=48.53 l=2.4
X5 out.t7 o1.t20 sky130_fd_pr__cap_mim_m3_1 l=29.96 w=29.96
X6 o1.t9 inn.t0 t1.t5 vdd.t16 sky130_fd_pr__pfet_01v8 ad=14.0737 pd=97.64 as=14.0737 ps=97.64 w=48.53 l=2.4
X7 vdd.t3 vdd.t0 vdd.t2 vdd.t1 sky130_fd_pr__pfet_01v8 ad=14.0737 pd=97.64 as=0 ps=0 w=48.53 l=2.4
X8 vdd.t7 vdd.t4 vdd.t6 vdd.t5 sky130_fd_pr__pfet_01v8 ad=14.0737 pd=97.64 as=0 ps=0 w=48.53 l=2.4
X9 out.t9 o1.t16 sky130_fd_pr__cap_mim_m3_1 l=29.96 w=29.96
X10 out.t12 o1.t10 sky130_fd_pr__cap_mim_m3_1 l=29.96 w=29.96
X11 out.t2 o1.t30 sky130_fd_pr__cap_mim_m3_1 l=29.96 w=29.96
X12 x1.t2 inp.t8 t1.t16 vdd.t19 sky130_fd_pr__pfet_01v8 ad=14.0737 pd=97.64 as=14.0737 ps=97.64 w=48.53 l=2.4
X13 o1.t4 inn.t5 t1.t2 vdd.t11 sky130_fd_pr__pfet_01v8 ad=14.0737 pd=97.64 as=14.0737 ps=97.64 w=48.53 l=2.4
X14 out.t5 o1.t24 sky130_fd_pr__cap_mim_m3_1 l=29.96 w=29.96
X15 t1.t0 s1t.t0 vdd.t28 vdd.t1 sky130_fd_pr__pfet_01v8 ad=7.0296 pd=49.06 as=7.0296 ps=49.06 w=24.24 l=2.4
X16 o1.t1 inn.t8 t1.t1 vdd.t8 sky130_fd_pr__pfet_01v8 ad=14.0737 pd=97.64 as=14.0737 ps=97.64 w=48.53 l=2.4
X17 x1.t6 inp.t4 t1.t18 vdd.t23 sky130_fd_pr__pfet_01v8 ad=14.0737 pd=97.64 as=14.0737 ps=97.64 w=48.53 l=2.4
X18 vss.t7 vss.t4 vss.t6 vss.t5 sky130_fd_pr__nfet_01v8 ad=8.1432 pd=56.74 as=0 ps=0 w=28.08 l=2.4
X19 x1.t3 inp.t7 t1.t15 vdd.t20 sky130_fd_pr__pfet_01v8 ad=14.0737 pd=97.64 as=14.0737 ps=97.64 w=48.53 l=2.4
X20 o1.t5 inn.t4 t1.t3 vdd.t12 sky130_fd_pr__pfet_01v8 ad=14.0737 pd=97.64 as=14.0737 ps=97.64 w=48.53 l=2.4
X21 out.t1 s2ld.t0 vss.t13 vss.t12 sky130_fd_pr__nfet_01v8 ad=1.044 pd=7.78 as=1.044 ps=7.78 w=3.6 l=0.15
X22 o1.t2 inn.t7 t1.t9 vdd.t9 sky130_fd_pr__pfet_01v8 ad=14.0737 pd=97.64 as=14.0737 ps=97.64 w=48.53 l=2.4
X23 vss.t11 vss.t8 vss.t10 vss.t9 sky130_fd_pr__nfet_01v8 ad=8.1432 pd=56.74 as=0 ps=0 w=28.08 l=2.4
X24 out.t0 o1.t32 vdd.t18 vdd.t17 sky130_fd_pr__pfet_01v8 ad=10.5705 pd=73.48 as=10.5705 ps=73.48 w=36.45 l=0.15
X25 o1.t6 inn.t3 t1.t4 vdd.t13 sky130_fd_pr__pfet_01v8 ad=14.0737 pd=97.64 as=14.0737 ps=97.64 w=48.53 l=2.4
X26 o1.t0 x1.t11 vss.t3 vss.t2 sky130_fd_pr__nfet_01v8 ad=8.1432 pd=56.74 as=8.1432 ps=56.74 w=28.08 l=2.4
X27 x1.t8 inp.t2 t1.t13 vdd.t25 sky130_fd_pr__pfet_01v8 ad=14.0737 pd=97.64 as=14.0737 ps=97.64 w=48.53 l=2.4
X28 x1.t1 x1.t0 vss.t1 vss.t0 sky130_fd_pr__nfet_01v8 ad=8.1432 pd=56.74 as=8.1432 ps=56.74 w=28.08 l=2.4
X29 out.t10 o1.t14 sky130_fd_pr__cap_mim_m3_1 l=29.96 w=29.96
X30 x1.t7 inp.t3 t1.t17 vdd.t24 sky130_fd_pr__pfet_01v8 ad=14.0737 pd=97.64 as=14.0737 ps=97.64 w=48.53 l=2.4
X31 out.t4 o1.t26 sky130_fd_pr__cap_mim_m3_1 l=29.96 w=29.96
X32 x1.t4 inp.t6 t1.t14 vdd.t21 sky130_fd_pr__pfet_01v8 ad=14.0737 pd=97.64 as=14.0737 ps=97.64 w=48.53 l=2.4
X33 out.t3 o1.t28 sky130_fd_pr__cap_mim_m3_1 l=29.96 w=29.96
X34 o1.t3 inn.t6 t1.t6 vdd.t10 sky130_fd_pr__pfet_01v8 ad=14.0737 pd=97.64 as=14.0737 ps=97.64 w=48.53 l=2.4
X35 out.t8 o1.t18 sky130_fd_pr__cap_mim_m3_1 l=29.96 w=29.96
X36 x1.t5 inp.t5 t1.t12 vdd.t22 sky130_fd_pr__pfet_01v8 ad=14.0737 pd=97.64 as=14.0737 ps=97.64 w=48.53 l=2.4
X37 out.t6 o1.t22 sky130_fd_pr__cap_mim_m3_1 l=29.96 w=29.96
R0 inn.n0 inn.t8 528.165
R1 inn.n7 inn.t0 527.162
R2 inn.n6 inn.t1 527.162
R3 inn.n5 inn.t2 527.162
R4 inn.n4 inn.t3 527.162
R5 inn.n3 inn.t4 527.162
R6 inn.n2 inn.t5 527.162
R7 inn.n1 inn.t6 527.162
R8 inn.n0 inn.t7 527.162
R9 inn inn.n7 31.0366
R10 inn.n1 inn.n0 1.00442
R11 inn.n2 inn.n1 1.00442
R12 inn.n3 inn.n2 1.00442
R13 inn.n4 inn.n3 1.00442
R14 inn.n5 inn.n4 1.00442
R15 inn.n6 inn.n5 1.00442
R16 inn.n7 inn.n6 1.00442
R17 inp.n0 inp.t8 528.79
R18 inp.n7 inp.t0 527.787
R19 inp.n6 inp.t1 527.787
R20 inp.n5 inp.t2 527.787
R21 inp.n4 inp.t3 527.787
R22 inp.n3 inp.t4 527.787
R23 inp.n2 inp.t5 527.787
R24 inp.n1 inp.t6 527.787
R25 inp.n0 inp.t7 527.787
R26 inp inp.n7 31.7642
R27 inp.n1 inp.n0 1.00442
R28 inp.n2 inp.n1 1.00442
R29 inp.n3 inp.n2 1.00442
R30 inp.n4 inp.n3 1.00442
R31 inp.n5 inp.n4 1.00442
R32 inp.n6 inp.n5 1.00442
R33 inp.n7 inp.n6 1.00442
R34 t1 t1.t0 73.6453
R35 t1 t1.n16 37.5109
R36 t1.n0 t1.t16 27.8057
R37 t1.n16 t1.t5 27.3038
R38 t1.n15 t1.t11 27.3038
R39 t1.n14 t1.t7 27.3038
R40 t1.n13 t1.t10 27.3038
R41 t1.n12 t1.t8 27.3038
R42 t1.n11 t1.t13 27.3038
R43 t1.n10 t1.t4 27.3038
R44 t1.n9 t1.t17 27.3038
R45 t1.n8 t1.t3 27.3038
R46 t1.n7 t1.t18 27.3038
R47 t1.n6 t1.t2 27.3038
R48 t1.n5 t1.t12 27.3038
R49 t1.n4 t1.t6 27.3038
R50 t1.n3 t1.t14 27.3038
R51 t1.n2 t1.t9 27.3038
R52 t1.n1 t1.t15 27.3038
R53 t1.n0 t1.t1 27.3038
R54 t1.n1 t1.n0 0.50246
R55 t1.n2 t1.n1 0.50246
R56 t1.n3 t1.n2 0.50246
R57 t1.n4 t1.n3 0.50246
R58 t1.n5 t1.n4 0.50246
R59 t1.n6 t1.n5 0.50246
R60 t1.n7 t1.n6 0.50246
R61 t1.n8 t1.n7 0.50246
R62 t1.n9 t1.n8 0.50246
R63 t1.n10 t1.n9 0.50246
R64 t1.n11 t1.n10 0.50246
R65 t1.n12 t1.n11 0.50246
R66 t1.n13 t1.n12 0.50246
R67 t1.n14 t1.n13 0.50246
R68 t1.n15 t1.n14 0.50246
R69 t1.n16 t1.n15 0.50246
R70 s1t s1t.t0 331.344
R71 out.n10 out.t0 69.9534
R72 out out.t1 64.265
R73 out.n0 out.t12 22.5044
R74 out.n9 out.t2 19.1373
R75 out.n8 out.t3 19.1373
R76 out.n7 out.t4 19.1373
R77 out.n6 out.t5 19.1373
R78 out.n5 out.t6 19.1373
R79 out.n4 out.t7 19.1373
R80 out.n3 out.t8 19.1373
R81 out.n2 out.t9 19.1373
R82 out.n1 out.t10 19.1373
R83 out.n0 out.t11 19.1373
R84 out out.n10 8.46963
R85 out.n10 out.n9 7.65648
R86 out.n1 out.n0 3.36758
R87 out.n2 out.n1 3.36758
R88 out.n3 out.n2 3.36758
R89 out.n4 out.n3 3.36758
R90 out.n5 out.n4 3.36758
R91 out.n6 out.n5 3.36758
R92 out.n7 out.n6 3.36758
R93 out.n8 out.n7 3.36758
R94 out.n9 out.n8 3.36758
R95 s2ld s2ld.t0 826.828
R96 o1.n8 o1.t32 6141.27
R97 o1 o1.t0 36.7512
R98 o1.n8 o1.n7 36.1112
R99 o1.n0 o1.t1 27.6827
R100 o1.n7 o1.t9 26.6788
R101 o1.n6 o1.t8 26.6788
R102 o1.n5 o1.t7 26.6788
R103 o1.n4 o1.t6 26.6788
R104 o1.n3 o1.t5 26.6788
R105 o1.n2 o1.t4 26.6788
R106 o1.n1 o1.t3 26.6788
R107 o1.n0 o1.t2 26.6788
R108 o1.n9 o1.t10 21.9132
R109 o1.n18 o1.t30 18.5461
R110 o1.n17 o1.t28 18.5461
R111 o1.n16 o1.t26 18.5461
R112 o1.n15 o1.t24 18.5461
R113 o1.n14 o1.t22 18.5461
R114 o1.n13 o1.t20 18.5461
R115 o1.n12 o1.t18 18.5461
R116 o1.n11 o1.t16 18.5461
R117 o1.n10 o1.t14 18.5461
R118 o1.n9 o1.t12 18.5461
R119 o1 o1.n19 8.23463
R120 o1.n19 o1.n8 4.67465
R121 o1.n19 o1.n18 4.2518
R122 o1.n10 o1.n9 3.36758
R123 o1.n11 o1.n10 3.36758
R124 o1.n12 o1.n11 3.36758
R125 o1.n13 o1.n12 3.36758
R126 o1.n14 o1.n13 3.36758
R127 o1.n15 o1.n14 3.36758
R128 o1.n16 o1.n15 3.36758
R129 o1.n17 o1.n16 3.36758
R130 o1.n18 o1.n17 3.36758
R131 o1.n1 o1.n0 1.00442
R132 o1.n2 o1.n1 1.00442
R133 o1.n3 o1.n2 1.00442
R134 o1.n4 o1.n3 1.00442
R135 o1.n5 o1.n4 1.00442
R136 o1.n6 o1.n5 1.00442
R137 o1.n7 o1.n6 1.00442
R138 x1.n9 x1.t11 324.31
R139 x1.n8 x1.t0 324.31
R140 x1 x1.n7 50.7999
R141 x1.n0 x1.t2 30.5673
R142 x1.n7 x1.t10 29.5634
R143 x1.n6 x1.t9 29.5634
R144 x1.n5 x1.t8 29.5634
R145 x1.n4 x1.t7 29.5634
R146 x1.n3 x1.t6 29.5634
R147 x1.n2 x1.t5 29.5634
R148 x1.n1 x1.t4 29.5634
R149 x1.n0 x1.t3 29.5634
R150 x1.n8 x1.t1 22.3003
R151 x1 x1.n9 19.1172
R152 x1.n1 x1.n0 1.00442
R153 x1.n2 x1.n1 1.00442
R154 x1.n3 x1.n2 1.00442
R155 x1.n4 x1.n3 1.00442
R156 x1.n5 x1.n4 1.00442
R157 x1.n6 x1.n5 1.00442
R158 x1.n7 x1.n6 1.00442
R159 x1.n9 x1.n8 0.46862
R160 vdd.n36 vdd.n15 80022.4
R161 vdd.n40 vdd.n15 80022.4
R162 vdd.n40 vdd.n14 80022.4
R163 vdd.n36 vdd.n14 80022.4
R164 vdd.n39 vdd.n38 8535.72
R165 vdd.n39 vdd.n16 8535.72
R166 vdd.n38 vdd.n37 8535.72
R167 vdd.n37 vdd.n16 8535.72
R168 vdd.n35 vdd.n9 1898.8
R169 vdd.n9 vdd.n34 1898.8
R170 vdd.n33 vdd.n8 1898.8
R171 vdd.n32 vdd.n8 1898.8
R172 vdd.n6 vdd.n31 1898.8
R173 vdd.n30 vdd.n6 1898.8
R174 vdd.n29 vdd.n7 1898.8
R175 vdd.n7 vdd.n28 1898.8
R176 vdd.n27 vdd.n5 1898.8
R177 vdd.n26 vdd.n5 1898.8
R178 vdd.n3 vdd.n25 1898.8
R179 vdd.n24 vdd.n3 1898.8
R180 vdd.n23 vdd.n4 1898.8
R181 vdd.n4 vdd.n22 1898.8
R182 vdd.n21 vdd.n2 1898.8
R183 vdd.n20 vdd.n2 1898.8
R184 vdd.n1 vdd.n19 1898.8
R185 vdd.n18 vdd.n1 1898.8
R186 vdd.n0 vdd.n13 1898.8
R187 vdd.n41 vdd.n11 1898.8
R188 vdd.n10 vdd.n42 1439.03
R189 vdd.n41 vdd.n10 980.999
R190 vdd.n9 vdd.t4 530.167
R191 vdd.n11 vdd.t0 530.167
R192 vdd.n10 vdd.t28 33.3241
R193 vdd.t1 vdd.n40 30.4399
R194 vdd.n11 vdd.t3 28.4822
R195 vdd.n9 vdd.t6 28.4336
R196 vdd.n9 vdd.t7 28.4336
R197 vdd.n11 vdd.t2 28.4336
R198 vdd.n10 vdd.t18 27.0956
R199 vdd.n41 vdd.t1 25.0069
R200 vdd.n18 vdd.t8 25.0069
R201 vdd.n19 vdd.t20 25.0069
R202 vdd.n20 vdd.t9 25.0069
R203 vdd.n21 vdd.t21 25.0069
R204 vdd.n22 vdd.t10 25.0069
R205 vdd.n23 vdd.t22 25.0069
R206 vdd.n24 vdd.t11 25.0069
R207 vdd.n25 vdd.t23 25.0069
R208 vdd.n26 vdd.t12 25.0069
R209 vdd.n27 vdd.t24 25.0069
R210 vdd.n28 vdd.t13 25.0069
R211 vdd.n29 vdd.t25 25.0069
R212 vdd.n30 vdd.t14 25.0069
R213 vdd.n31 vdd.t26 25.0069
R214 vdd.n32 vdd.t15 25.0069
R215 vdd.n33 vdd.t27 25.0069
R216 vdd.n34 vdd.t16 25.0069
R217 vdd.n35 vdd.t5 25.0069
R218 vdd.n36 vdd.n35 21.7243
R219 vdd.t8 vdd.n13 18.4906
R220 vdd.t20 vdd.n18 18.4906
R221 vdd.n19 vdd.t9 18.4906
R222 vdd.t21 vdd.n20 18.4906
R223 vdd.t10 vdd.n21 18.4906
R224 vdd.n22 vdd.t22 18.4906
R225 vdd.t11 vdd.n23 18.4906
R226 vdd.t23 vdd.n24 18.4906
R227 vdd.t24 vdd.n26 18.4906
R228 vdd.t13 vdd.n27 18.4906
R229 vdd.n28 vdd.t25 18.4906
R230 vdd.t14 vdd.n29 18.4906
R231 vdd.t26 vdd.n30 18.4906
R232 vdd.n31 vdd.t15 18.4906
R233 vdd.t27 vdd.n32 18.4906
R234 vdd.t16 vdd.n33 18.4906
R235 vdd.n34 vdd.t5 18.4906
R236 vdd.n42 vdd.n13 18.3277
R237 vdd.n38 vdd.n12 17.4613
R238 vdd.n17 vdd.t12 13.6033
R239 vdd.t17 vdd.n41 9.327
R240 vdd vdd.n10 9.22568
R241 vdd.t19 vdd.t17 9.1641
R242 vdd.n9 vdd.n12 7.3916
R243 vdd.n42 vdd.t19 6.67974
R244 vdd.n25 vdd.n17 4.88775
R245 vdd.n17 vdd.n15 0.571488
R246 vdd.n38 vdd.n15 0.571488
R247 vdd.n17 vdd.n14 0.571488
R248 vdd.n16 vdd.n14 0.571488
R249 vdd.n40 vdd.n39 0.546223
R250 vdd.n37 vdd.n36 0.546223
R251 vdd vdd.n12 0.458388
R252 vdd.n9 vdd.n8 0.193562
R253 vdd.n8 vdd.n6 0.193562
R254 vdd.n7 vdd.n6 0.193562
R255 vdd.n7 vdd.n5 0.193562
R256 vdd.n5 vdd.n3 0.193562
R257 vdd.n4 vdd.n3 0.193562
R258 vdd.n4 vdd.n2 0.193562
R259 vdd.n2 vdd.n1 0.193562
R260 vdd.n1 vdd.n0 0.193562
R261 vdd.n0 vdd.n11 0.128213
R262 vss.n6 vss.n5 41271.5
R263 vss.n8 vss.n6 41271.5
R264 vss.n12 vss.n8 41271.5
R265 vss.n12 vss.n5 41271.5
R266 vss.n10 vss.n4 2681.6
R267 vss.n11 vss.n10 2681.6
R268 vss.n9 vss.n4 2681.6
R269 vss.n11 vss.n9 2681.6
R270 vss.n15 vss.n0 1120.69
R271 vss.n0 vss.n14 1120.69
R272 vss.n1 vss.n3 1120.69
R273 vss.n7 vss.n2 1120.69
R274 vss.n0 vss.t8 323.18
R275 vss.n2 vss.t4 323.18
R276 vss.n0 vss.n16 282.663
R277 vss.n8 vss.t5 91.5259
R278 vss.t5 vss.n7 72.0356
R279 vss.t0 vss.n3 72.0356
R280 vss.n14 vss.t2 72.0356
R281 vss.n15 vss.t9 72.0356
R282 vss.n16 vss.n5 69.3421
R283 vss.n7 vss.t0 52.0951
R284 vss.n14 vss.t9 52.0951
R285 vss.n13 vss.n3 48.9794
R286 vss.n0 vss.t13 48.2346
R287 vss.n16 vss.t12 43.9943
R288 vss.t12 vss.n15 24.0537
R289 vss.n2 vss.t7 21.1303
R290 vss.n0 vss.t10 21.0817
R291 vss.n0 vss.t11 21.0817
R292 vss.n1 vss.t3 21.0817
R293 vss.n2 vss.t1 21.0817
R294 vss.n2 vss.t6 21.0817
R295 vss vss.n4 11.4094
R296 vss.n13 vss.n6 7.69787
R297 vss.n6 vss.n4 7.69787
R298 vss.n13 vss.n12 7.69787
R299 vss.n12 vss.n11 7.69787
R300 vss.n10 vss.n8 4.53538
R301 vss.n9 vss.n5 4.53538
R302 vss.t2 vss.n13 3.11621
R303 vss vss.n0 2.2037
R304 vss.n0 vss.n1 0.216429
R305 vss.n2 vss.n1 0.131919
C0 vdd out 10.3734f
C1 vdd inp 18.7654f
C2 vdd t1 0.13352p
C3 o1 inn 39.1274f
C4 s1t o1 0.11197f
C5 x1 o1 3.68899f
C6 x1 inn 0.58271f
C7 s1t x1 0
C8 o1 out 0.91265p
C9 inp o1 12.4957f
C10 o1 s2ld 0.16758f
C11 inp inn 13.296f
C12 s1t out 12.3177f
C13 x1 out 13.5143f
C14 inp x1 39.2894f
C15 t1 o1 25.0112f
C16 x1 s2ld 0
C17 t1 inn 38.7961f
C18 t1 s1t 14.8708f
C19 t1 x1 14.0047f
C20 s2ld out 1.45556f
C21 vdd o1 54.1726f
C22 t1 out 0.12574f
C23 vdd inn 19.1548f
C24 t1 inp 38.8436f
C25 vdd s1t 6.06857f
C26 vdd x1 66.87479f
C27 inn vss 22.59865f
C28 inp vss 12.20055f
C29 t1 vss 52.20805f
C30 s1t vss 30.62627f
C31 out vss 0.11486p
C32 s2ld vss 4.83004f
C33 o1 vss 0.29032p
C34 x1 vss 0.14028p
C35 vdd vss 1.65842p
C36 vss.t13 vss 0.03027f
C37 vss.t3 vss 2.18687f
C38 vss.t1 vss 2.18687f
C39 vdd.n0 vss 0.52605f
C40 vdd.n1 vss 1.05209f
C41 vdd.n2 vss 1.05209f
C42 vdd.n3 vss 1.05209f
C43 vdd.n4 vss 1.05209f
C44 vdd.n5 vss 1.05209f
C45 vdd.n6 vss 1.05209f
C46 vdd.n7 vss 1.05209f
C47 vdd.n8 vss 1.05209f
C48 vdd.n9 vss 10.3065f
C49 vdd.n10 vss 11.9264f
C50 vdd.n11 vss 1.48498f
C51 vdd.n12 vss 24.2254f
C52 vdd.t18 vss 0.60985f
C53 vdd.n13 vss 4.80582f
C54 vdd.t3 vss 1.33209f
C55 vdd.t2 vss 1.33163f
C56 vdd.n14 vss 0.32702f
C57 vdd.n15 vss 0.32702f
C58 vdd.n16 vss 0.75891f
C59 vdd.t5 vss 5.27993f
C60 vdd.t15 vss 5.27993f
C61 vdd.t25 vss 5.27993f
C62 vdd.t12 vss 4.68668f
C63 vdd.n17 vss 2.24446f
C64 vdd.t22 vss 5.27993f
C65 vdd.t9 vss 5.27993f
C66 vdd.t8 vss 5.27993f
C67 vdd.n18 vss 5.6166f
C68 vdd.t20 vss 5.27993f
C69 vdd.n19 vss 5.6166f
C70 vdd.n20 vss 5.6166f
C71 vdd.t21 vss 5.27993f
C72 vdd.n21 vss 5.6166f
C73 vdd.t10 vss 5.27993f
C74 vdd.n22 vss 5.6166f
C75 vdd.n23 vss 5.6166f
C76 vdd.t11 vss 5.27993f
C77 vdd.n24 vss 5.6166f
C78 vdd.t23 vss 5.27993f
C79 vdd.n25 vss 3.96539f
C80 vdd.n26 vss 5.6166f
C81 vdd.t24 vss 5.27993f
C82 vdd.n27 vss 5.6166f
C83 vdd.t13 vss 5.27993f
C84 vdd.n28 vss 5.6166f
C85 vdd.n29 vss 5.6166f
C86 vdd.t14 vss 5.27993f
C87 vdd.n30 vss 5.6166f
C88 vdd.t26 vss 5.27993f
C89 vdd.n31 vss 5.6166f
C90 vdd.n32 vss 5.6166f
C91 vdd.t27 vss 5.27993f
C92 vdd.n33 vss 5.6166f
C93 vdd.t16 vss 5.27993f
C94 vdd.n34 vss 5.6166f
C95 vdd.t7 vss 1.33163f
C96 vdd.t6 vss 1.33163f
C97 vdd.n35 vss 6.02063f
C98 vdd.n36 vss 3.34405f
C99 vdd.n37 vss 0.327f
C100 vdd.n38 vss 6.06523f
C101 vdd.n39 vss 0.327f
C102 vdd.n40 vss 4.4053f
C103 vdd.t1 vss 6.73863f
C104 vdd.t28 vss 4.20075f
C105 vdd.n41 vss 4.67749f
C106 vdd.t17 vss 2.24446f
C107 vdd.t19 vss 1.92312f
C108 vdd.n42 vss 3.29022f
C109 x1.t2 vss 7.1428f
C110 x1.t3 vss 7.10835f
C111 x1.n0 vss 2.09233f
C112 x1.t4 vss 7.10835f
C113 x1.n1 vss 1.16635f
C114 x1.t5 vss 7.10835f
C115 x1.n2 vss 1.16635f
C116 x1.t6 vss 7.10835f
C117 x1.n3 vss 1.16635f
C118 x1.t7 vss 7.10835f
C119 x1.n4 vss 1.16635f
C120 x1.t8 vss 7.10835f
C121 x1.n5 vss 1.16635f
C122 x1.t9 vss 7.10835f
C123 x1.n6 vss 1.16635f
C124 x1.t10 vss 7.10835f
C125 x1.n7 vss 15.6451f
C126 x1.t1 vss 3.85246f
C127 x1.n8 vss 2.16883f
C128 x1.n9 vss 4.75254f
C129 o1.t1 vss 6.66789f
C130 o1.t2 vss 6.63186f
C131 o1.n0 vss 2.01362f
C132 o1.t3 vss 6.63186f
C133 o1.n1 vss 1.12814f
C134 o1.t4 vss 6.63186f
C135 o1.n2 vss 1.12814f
C136 o1.t5 vss 6.63186f
C137 o1.n3 vss 1.12814f
C138 o1.t6 vss 6.63186f
C139 o1.n4 vss 1.12814f
C140 o1.t7 vss 6.63186f
C141 o1.n5 vss 1.12814f
C142 o1.t8 vss 6.63186f
C143 o1.n6 vss 1.12814f
C144 o1.t9 vss 6.63186f
C145 o1.n7 vss 8.55473f
C146 o1.n8 vss 23.9834f
C147 o1.t10 vss 0.16183p
C148 o1.t12 vss 0.16159p
C149 o1.n9 vss 2.58464f
C150 o1.t14 vss 0.16159p
C151 o1.n10 vss 1.73281f
C152 o1.t16 vss 0.16159p
C153 o1.n11 vss 1.73281f
C154 o1.t18 vss 0.16159p
C155 o1.n12 vss 1.73281f
C156 o1.t20 vss 0.16159p
C157 o1.n13 vss 1.73281f
C158 o1.t22 vss 0.16159p
C159 o1.n14 vss 1.73281f
C160 o1.t24 vss 0.16159p
C161 o1.n15 vss 1.73281f
C162 o1.t26 vss 0.16159p
C163 o1.n16 vss 1.73281f
C164 o1.t28 vss 0.16159p
C165 o1.n17 vss 1.73281f
C166 o1.t30 vss 0.16159p
C167 o1.n18 vss 1.33613f
C168 o1.n19 vss 28.6039f
C169 o1.t0 vss 5.3148f
C170 out.t0 vss 4.95419f
C171 out.n0 vss 1.43871f
C172 out.n1 vss 0.96216f
C173 out.n2 vss 0.96216f
C174 out.n3 vss 0.96216f
C175 out.n4 vss 0.96216f
C176 out.n5 vss 0.96216f
C177 out.n6 vss 0.96216f
C178 out.n7 vss 0.96216f
C179 out.n8 vss 0.96216f
C180 out.n9 vss 1.29991f
C181 out.n10 vss 21.9524f
C182 out.t1 vss 0.68675f
C183 t1.t0 vss 22.23263f
C184 t1.t16 vss 11.65705f
C185 t1.t1 vss 11.22297f
C186 t1.n0 vss 4.6103f
C187 t1.t15 vss 11.61447f
C188 t1.n1 vss 2.45837f
C189 t1.t9 vss 11.22025f
C190 t1.n2 vss 2.45837f
C191 t1.t14 vss 11.61447f
C192 t1.n3 vss 2.45837f
C193 t1.t6 vss 11.22025f
C194 t1.n4 vss 2.45837f
C195 t1.t12 vss 11.61447f
C196 t1.n5 vss 2.45837f
C197 t1.t2 vss 11.22025f
C198 t1.n6 vss 2.45837f
C199 t1.t18 vss 11.61447f
C200 t1.n7 vss 2.45837f
C201 t1.t3 vss 11.22025f
C202 t1.n8 vss 2.45837f
C203 t1.t17 vss 11.61447f
C204 t1.n9 vss 2.45837f
C205 t1.t4 vss 11.22025f
C206 t1.n10 vss 2.45837f
C207 t1.t13 vss 11.61447f
C208 t1.n11 vss 2.45837f
C209 t1.t8 vss 11.22025f
C210 t1.n12 vss 2.45837f
C211 t1.t10 vss 11.61447f
C212 t1.n13 vss 2.45837f
C213 t1.t7 vss 11.22025f
C214 t1.n14 vss 2.45837f
C215 t1.t11 vss 11.61447f
C216 t1.n15 vss 2.45837f
C217 t1.t5 vss 11.22025f
C218 t1.n16 vss 23.486f
C219 inp.n0 vss 6.58257f
C220 inp.n1 vss 3.41666f
C221 inp.n2 vss 3.41666f
C222 inp.n3 vss 3.41666f
C223 inp.n4 vss 3.41666f
C224 inp.n5 vss 3.41666f
C225 inp.n6 vss 3.41666f
C226 inp.n7 vss 11.1912f
C227 inn.n0 vss 5.93302f
C228 inn.n1 vss 3.08049f
C229 inn.n2 vss 3.08049f
C230 inn.n3 vss 3.08049f
C231 inn.n4 vss 3.08049f
C232 inn.n5 vss 3.08049f
C233 inn.n6 vss 3.08049f
C234 inn.n7 vss 9.97865f
.ends
