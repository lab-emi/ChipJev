* NGSPICE file created from layout.ext - technology: sky130A

.subckt layout inn inp out s1t t1 vdd vss x1
X0 vdd.t27 vdd.t24 vdd.t26 vdd.t25 sky130_fd_pr__pfet_01v8 ad=14.4623 pd=100.32 as=0 ps=0 w=49.87 l=2.4
X1 out.t2 inn.t13 t1.t10 vdd.t8 sky130_fd_pr__pfet_01v8 ad=14.4623 pd=100.32 as=14.4623 ps=100.32 w=49.87 l=2.4
X2 vdd.t23 vdd.t21 vdd.t22 vdd.t14 sky130_fd_pr__pfet_01v8 ad=14.4623 pd=100.32 as=0 ps=0 w=49.87 l=2.4
X3 out.t12 inn.t9 t1.t14 vdd.t4 sky130_fd_pr__pfet_01v8 ad=14.4623 pd=100.32 as=14.4623 ps=100.32 w=49.87 l=2.4
X4 out.t16 inn.t16 t1.t7 vdd.t5 sky130_fd_pr__pfet_01v8 ad=14.4623 pd=100.32 as=14.4623 ps=100.32 w=49.87 l=2.4
X5 vdd.t20 vdd.t17 vdd.t19 vdd.t18 sky130_fd_pr__pfet_01v8 ad=14.4623 pd=100.32 as=0 ps=0 w=49.87 l=2.4
X6 out.t4 inn.t6 t1.t17 vdd.t7 sky130_fd_pr__pfet_01v8 ad=14.4623 pd=100.32 as=14.4623 ps=100.32 w=49.87 l=2.4
X7 out.t18 inn.t12 t1.t11 vdd.t9 sky130_fd_pr__pfet_01v8 ad=14.4623 pd=100.32 as=14.4623 ps=100.32 w=49.87 l=2.4
X8 x1.t15 inp.t8 t1.t35 vdd.t29 sky130_fd_pr__pfet_01v8 ad=14.4623 pd=100.32 as=14.4623 ps=100.32 w=49.87 l=2.4
X9 x1.t18 inp.t4 t1.t36 vdd.t33 sky130_fd_pr__pfet_01v8 ad=14.4623 pd=100.32 as=14.4623 ps=100.32 w=49.87 l=2.4
X10 out.t11 inn.t14 t1.t9 vdd.t7 sky130_fd_pr__pfet_01v8 ad=14.4623 pd=100.32 as=14.4623 ps=100.32 w=49.87 l=2.4
X11 out.t3 inn.t15 t1.t8 vdd.t6 sky130_fd_pr__pfet_01v8 ad=14.4623 pd=100.32 as=14.4623 ps=100.32 w=49.87 l=2.4
X12 out.t7 inn.t4 t1.t19 vdd.t9 sky130_fd_pr__pfet_01v8 ad=14.4623 pd=100.32 as=14.4623 ps=100.32 w=49.87 l=2.4
X13 x1.t8 inp.t14 t1.t28 vdd.t31 sky130_fd_pr__pfet_01v8 ad=14.4623 pd=100.32 as=14.4623 ps=100.32 w=49.87 l=2.4
X14 x1.t6 inp.t7 t1.t26 vdd.t30 sky130_fd_pr__pfet_01v8 ad=14.4623 pd=100.32 as=14.4623 ps=100.32 w=49.87 l=2.4
X15 x1.t1 inp.t3 t1.t1 vdd.t34 sky130_fd_pr__pfet_01v8 ad=14.4623 pd=100.32 as=14.4623 ps=100.32 w=49.87 l=2.4
X16 x1.t13 inp.t11 t1.t33 vdd.t34 sky130_fd_pr__pfet_01v8 ad=14.4623 pd=100.32 as=14.4623 ps=100.32 w=49.87 l=2.4
X17 out.t5 inn.t7 t1.t16 vdd.t6 sky130_fd_pr__pfet_01v8 ad=14.4623 pd=100.32 as=14.4623 ps=100.32 w=49.87 l=2.4
X18 out.t17 inn.t3 t1.t20 vdd.t10 sky130_fd_pr__pfet_01v8 ad=14.4623 pd=100.32 as=14.4623 ps=100.32 w=49.87 l=2.4
X19 vdd.t16 vdd.t13 vdd.t15 vdd.t14 sky130_fd_pr__pfet_01v8 ad=14.4623 pd=100.32 as=0 ps=0 w=49.87 l=2.4
X20 out.t9 inn.t17 t1.t6 vdd.t4 sky130_fd_pr__pfet_01v8 ad=14.4623 pd=100.32 as=14.4623 ps=100.32 w=49.87 l=2.4
X21 x1.t3 inp.t2 t1.t3 vdd.t35 sky130_fd_pr__pfet_01v8 ad=14.4623 pd=100.32 as=14.4623 ps=100.32 w=49.87 l=2.4
X22 vss.t3 vss.t0 vss.t2 vss.t1 sky130_fd_pr__nfet_01v8 ad=5.2606 pd=36.86 as=0 ps=0 w=18.14 l=2.4
X23 out.t13 inn.t11 t1.t12 vdd.t10 sky130_fd_pr__pfet_01v8 ad=14.4623 pd=100.32 as=14.4623 ps=100.32 w=49.87 l=2.4
X24 out.t10 inn.t2 t1.t21 vdd.t11 sky130_fd_pr__pfet_01v8 ad=14.4623 pd=100.32 as=14.4623 ps=100.32 w=49.87 l=2.4
X25 x1.t11 inp.t17 t1.t31 vdd.t28 sky130_fd_pr__pfet_01v8 ad=14.4623 pd=100.32 as=14.4623 ps=100.32 w=49.87 l=2.4
X26 x1.t2 inp.t1 t1.t2 vdd.t18 sky130_fd_pr__pfet_01v8 ad=14.4623 pd=100.32 as=14.4623 ps=100.32 w=49.87 l=2.4
X27 vss.t7 vss.t4 vss.t6 vss.t5 sky130_fd_pr__nfet_01v8 ad=5.2606 pd=36.86 as=0 ps=0 w=18.14 l=2.4
X28 x1.t0 inp.t0 t1.t0 vdd.t2 sky130_fd_pr__pfet_01v8 ad=14.4623 pd=100.32 as=14.4623 ps=100.32 w=49.87 l=2.4
X29 x1.t4 inp.t16 t1.t24 vdd.t29 sky130_fd_pr__pfet_01v8 ad=14.4623 pd=100.32 as=14.4623 ps=100.32 w=49.87 l=2.4
X30 x1.t14 inp.t10 t1.t34 vdd.t35 sky130_fd_pr__pfet_01v8 ad=14.4623 pd=100.32 as=14.4623 ps=100.32 w=49.87 l=2.4
X31 out.t15 inn.t0 t1.t23 vdd.t12 sky130_fd_pr__pfet_01v8 ad=14.4623 pd=100.32 as=14.4623 ps=100.32 w=49.87 l=2.4
X32 out.t1 x1.t20 vss.t9 vss.t8 sky130_fd_pr__nfet_01v8 ad=5.2606 pd=36.86 as=5.2606 ps=36.86 w=18.14 l=2.4
X33 x1.t19 inp.t9 t1.t37 vdd.t28 sky130_fd_pr__pfet_01v8 ad=14.4623 pd=100.32 as=14.4623 ps=100.32 w=49.87 l=2.4
X34 x1.t5 inp.t5 t1.t25 vdd.t32 sky130_fd_pr__pfet_01v8 ad=14.4623 pd=100.32 as=14.4623 ps=100.32 w=49.87 l=2.4
X35 x1.t17 x1.t16 vss.t11 vss.t10 sky130_fd_pr__nfet_01v8 ad=5.2606 pd=36.86 as=5.2606 ps=36.86 w=18.14 l=2.4
X36 x1.t12 inp.t6 t1.t32 vdd.t31 sky130_fd_pr__pfet_01v8 ad=14.4623 pd=100.32 as=14.4623 ps=100.32 w=49.87 l=2.4
X37 out.t0 inn.t5 t1.t18 vdd.t8 sky130_fd_pr__pfet_01v8 ad=14.4623 pd=100.32 as=14.4623 ps=100.32 w=49.87 l=2.4
X38 x1.t7 inp.t13 t1.t27 vdd.t32 sky130_fd_pr__pfet_01v8 ad=14.4623 pd=100.32 as=14.4623 ps=100.32 w=49.87 l=2.4
X39 out.t6 inn.t10 t1.t13 vdd.t11 sky130_fd_pr__pfet_01v8 ad=14.4623 pd=100.32 as=14.4623 ps=100.32 w=49.87 l=2.4
X40 t1.t4 s1t.t0 vdd.t3 vdd.t2 sky130_fd_pr__pfet_01v8 ad=11.1708 pd=77.62 as=11.1708 ps=77.62 w=38.52 l=2.4
X41 out.t14 inn.t1 t1.t22 vdd.t0 sky130_fd_pr__pfet_01v8 ad=14.4623 pd=100.32 as=14.4623 ps=100.32 w=49.87 l=2.4
X42 x1.t10 inp.t12 t1.t30 vdd.t33 sky130_fd_pr__pfet_01v8 ad=14.4623 pd=100.32 as=14.4623 ps=100.32 w=49.87 l=2.4
X43 out.t8 inn.t8 t1.t15 vdd.t5 sky130_fd_pr__pfet_01v8 ad=14.4623 pd=100.32 as=14.4623 ps=100.32 w=49.87 l=2.4
X44 x1.t9 inp.t15 t1.t29 vdd.t30 sky130_fd_pr__pfet_01v8 ad=14.4623 pd=100.32 as=14.4623 ps=100.32 w=49.87 l=2.4
X45 t1.t5 s1t.t1 vdd.t1 vdd.t0 sky130_fd_pr__pfet_01v8 ad=11.1708 pd=77.62 as=11.1708 ps=77.62 w=38.52 l=2.4
R0 s1t.n0 s1t.t1 434.478
R1 s1t.n0 s1t.t0 433.976
R2 s1t s1t.n0 5.78353
R3 out.n16 out.t1 39.0394
R4 out.n7 out.t12 27.8746
R5 out.n0 out.t9 27.8746
R6 out.n15 out.t15 26.8707
R7 out.n14 out.t14 26.8707
R8 out.n13 out.t10 26.8707
R9 out.n12 out.t17 26.8707
R10 out.n11 out.t7 26.8707
R11 out.n10 out.t0 26.8707
R12 out.n9 out.t4 26.8707
R13 out.n8 out.t5 26.8707
R14 out.n7 out.t8 26.8707
R15 out.n6 out.t6 26.8707
R16 out.n5 out.t13 26.8707
R17 out.n4 out.t18 26.8707
R18 out.n3 out.t2 26.8707
R19 out.n2 out.t11 26.8707
R20 out.n1 out.t3 26.8707
R21 out.n0 out.t16 26.8707
R22 out out.n6 7.16956
R23 out out.n16 5.89242
R24 out.n16 out.n15 5.16172
R25 out.n8 out.n7 1.00442
R26 out.n9 out.n8 1.00442
R27 out.n10 out.n9 1.00442
R28 out.n11 out.n10 1.00442
R29 out.n12 out.n11 1.00442
R30 out.n13 out.n12 1.00442
R31 out.n14 out.n13 1.00442
R32 out.n15 out.n14 1.00442
R33 out.n1 out.n0 1.00442
R34 out.n2 out.n1 1.00442
R35 out.n3 out.n2 1.00442
R36 out.n4 out.n3 1.00442
R37 out.n5 out.n4 1.00442
R38 out.n6 out.n5 1.00442
R39 inn.n7 inn.t9 541.621
R40 inn.n0 inn.t17 541.621
R41 inn.n15 inn.t0 540.617
R42 inn.n14 inn.t1 540.617
R43 inn.n13 inn.t2 540.617
R44 inn.n12 inn.t3 540.617
R45 inn.n11 inn.t4 540.617
R46 inn.n10 inn.t5 540.617
R47 inn.n9 inn.t6 540.617
R48 inn.n8 inn.t7 540.617
R49 inn.n7 inn.t8 540.617
R50 inn.n6 inn.t10 540.617
R51 inn.n5 inn.t11 540.617
R52 inn.n4 inn.t12 540.617
R53 inn.n3 inn.t13 540.617
R54 inn.n2 inn.t14 540.617
R55 inn.n1 inn.t15 540.617
R56 inn.n0 inn.t16 540.617
R57 inn inn.n15 10.4967
R58 inn inn.n6 6.61261
R59 inn.n8 inn.n7 1.00442
R60 inn.n9 inn.n8 1.00442
R61 inn.n10 inn.n9 1.00442
R62 inn.n11 inn.n10 1.00442
R63 inn.n12 inn.n11 1.00442
R64 inn.n13 inn.n12 1.00442
R65 inn.n14 inn.n13 1.00442
R66 inn.n15 inn.n14 1.00442
R67 inn.n1 inn.n0 1.00442
R68 inn.n2 inn.n1 1.00442
R69 inn.n3 inn.n2 1.00442
R70 inn.n4 inn.n3 1.00442
R71 inn.n5 inn.n4 1.00442
R72 inn.n6 inn.n5 1.00442
R73 x1.n8 x1.t20 222.573
R74 x1.n7 x1.t16 222.573
R75 x1.n0 x1.t11 30.7112
R76 x1.n9 x1.t19 30.0862
R77 x1.n6 x1.t14 29.7073
R78 x1.n5 x1.t13 29.7073
R79 x1.n4 x1.t10 29.7073
R80 x1.n3 x1.t7 29.7073
R81 x1.n2 x1.t8 29.7073
R82 x1.n1 x1.t9 29.7073
R83 x1.n0 x1.t4 29.7073
R84 x1.n17 x1.t0 29.0823
R85 x1.n16 x1.t2 29.0823
R86 x1.n15 x1.t3 29.0823
R87 x1.n14 x1.t1 29.0823
R88 x1.n13 x1.t18 29.0823
R89 x1.n12 x1.t5 29.0823
R90 x1.n11 x1.t12 29.0823
R91 x1.n10 x1.t6 29.0823
R92 x1.n9 x1.t15 29.0823
R93 x1.n18 x1.n8 21.7969
R94 x1.n7 x1.t17 19.6286
R95 x1 x1.n6 8.34832
R96 x1.n18 x1.n17 6.34048
R97 x1 x1.n18 6.01462
R98 x1.n10 x1.n9 1.00442
R99 x1.n11 x1.n10 1.00442
R100 x1.n12 x1.n11 1.00442
R101 x1.n13 x1.n12 1.00442
R102 x1.n14 x1.n13 1.00442
R103 x1.n15 x1.n14 1.00442
R104 x1.n16 x1.n15 1.00442
R105 x1.n17 x1.n16 1.00442
R106 x1.n1 x1.n0 1.00442
R107 x1.n2 x1.n1 1.00442
R108 x1.n3 x1.n2 1.00442
R109 x1.n4 x1.n3 1.00442
R110 x1.n5 x1.n4 1.00442
R111 x1.n6 x1.n5 1.00442
R112 x1.n8 x1.n7 0.46862
R113 t1.n16 t1.t4 32.2075
R114 t1.n15 t1.t5 32.2075
R115 t1.n0 t1.t31 28.6227
R116 t1.n14 t1.t13 28.1207
R117 t1.n13 t1.t34 28.1207
R118 t1.n12 t1.t12 28.1207
R119 t1.n11 t1.t33 28.1207
R120 t1.n10 t1.t11 28.1207
R121 t1.n9 t1.t30 28.1207
R122 t1.n8 t1.t10 28.1207
R123 t1.n7 t1.t27 28.1207
R124 t1.n6 t1.t9 28.1207
R125 t1.n5 t1.t28 28.1207
R126 t1.n4 t1.t8 28.1207
R127 t1.n3 t1.t29 28.1207
R128 t1.n2 t1.t7 28.1207
R129 t1.n1 t1.t24 28.1207
R130 t1.n0 t1.t6 28.1207
R131 t1.n17 t1.t37 27.9977
R132 t1.n35 t1.t23 27.4957
R133 t1.n34 t1.t0 27.4957
R134 t1.n33 t1.t22 27.4957
R135 t1.n32 t1.t2 27.4957
R136 t1.n31 t1.t21 27.4957
R137 t1.n30 t1.t3 27.4957
R138 t1.n29 t1.t20 27.4957
R139 t1.n28 t1.t1 27.4957
R140 t1.n27 t1.t19 27.4957
R141 t1.n26 t1.t36 27.4957
R142 t1.n25 t1.t18 27.4957
R143 t1.n24 t1.t25 27.4957
R144 t1.n23 t1.t17 27.4957
R145 t1.n22 t1.t32 27.4957
R146 t1.n21 t1.t16 27.4957
R147 t1.n20 t1.t26 27.4957
R148 t1.n19 t1.t15 27.4957
R149 t1.n18 t1.t35 27.4957
R150 t1.n17 t1.t14 27.4957
R151 t1 t1.n35 11.8799
R152 t1 t1.n16 6.11488
R153 t1.n15 t1.n14 1.25728
R154 t1.n18 t1.n17 0.50246
R155 t1.n19 t1.n18 0.50246
R156 t1.n20 t1.n19 0.50246
R157 t1.n21 t1.n20 0.50246
R158 t1.n22 t1.n21 0.50246
R159 t1.n23 t1.n22 0.50246
R160 t1.n24 t1.n23 0.50246
R161 t1.n25 t1.n24 0.50246
R162 t1.n26 t1.n25 0.50246
R163 t1.n27 t1.n26 0.50246
R164 t1.n28 t1.n27 0.50246
R165 t1.n29 t1.n28 0.50246
R166 t1.n30 t1.n29 0.50246
R167 t1.n31 t1.n30 0.50246
R168 t1.n32 t1.n31 0.50246
R169 t1.n33 t1.n32 0.50246
R170 t1.n34 t1.n33 0.50246
R171 t1.n35 t1.n34 0.50246
R172 t1.n1 t1.n0 0.50246
R173 t1.n2 t1.n1 0.50246
R174 t1.n3 t1.n2 0.50246
R175 t1.n4 t1.n3 0.50246
R176 t1.n5 t1.n4 0.50246
R177 t1.n6 t1.n5 0.50246
R178 t1.n7 t1.n6 0.50246
R179 t1.n8 t1.n7 0.50246
R180 t1.n9 t1.n8 0.50246
R181 t1.n10 t1.n9 0.50246
R182 t1.n11 t1.n10 0.50246
R183 t1.n12 t1.n11 0.50246
R184 t1.n13 t1.n12 0.50246
R185 t1.n14 t1.n13 0.50246
R186 t1.n16 t1.n15 0.50246
R187 inp.n7 inp.t9 542.246
R188 inp.n0 inp.t17 542.246
R189 inp.n15 inp.t0 541.242
R190 inp.n14 inp.t1 541.242
R191 inp.n13 inp.t2 541.242
R192 inp.n12 inp.t3 541.242
R193 inp.n11 inp.t4 541.242
R194 inp.n10 inp.t5 541.242
R195 inp.n9 inp.t6 541.242
R196 inp.n8 inp.t7 541.242
R197 inp.n7 inp.t8 541.242
R198 inp.n6 inp.t10 541.242
R199 inp.n5 inp.t11 541.242
R200 inp.n4 inp.t12 541.242
R201 inp.n3 inp.t13 541.242
R202 inp.n2 inp.t14 541.242
R203 inp.n1 inp.t15 541.242
R204 inp.n0 inp.t16 541.242
R205 inp inp.n15 11.2243
R206 inp inp.n6 7.34017
R207 inp.n8 inp.n7 1.00442
R208 inp.n9 inp.n8 1.00442
R209 inp.n10 inp.n9 1.00442
R210 inp.n11 inp.n10 1.00442
R211 inp.n12 inp.n11 1.00442
R212 inp.n13 inp.n12 1.00442
R213 inp.n14 inp.n13 1.00442
R214 inp.n15 inp.n14 1.00442
R215 inp.n1 inp.n0 1.00442
R216 inp.n2 inp.n1 1.00442
R217 inp.n3 inp.n2 1.00442
R218 inp.n4 inp.n3 1.00442
R219 inp.n5 inp.n4 1.00442
R220 inp.n6 inp.n5 1.00442
R221 vdd.n23 vdd.n19 88930.6
R222 vdd.n54 vdd.n19 88930.6
R223 vdd.n59 vdd.n54 88930.6
R224 vdd.n59 vdd.n23 88930.6
R225 vdd.n57 vdd.n56 9485.93
R226 vdd.n58 vdd.n57 9485.93
R227 vdd.n56 vdd.n55 9485.93
R228 vdd.n58 vdd.n55 9485.93
R229 vdd.n3 vdd.n70 1950.12
R230 vdd.n69 vdd.n6 1950.12
R231 vdd.n68 vdd.n67 1950.12
R232 vdd.n66 vdd.n12 1950.12
R233 vdd.n65 vdd.n64 1950.12
R234 vdd.n63 vdd.n62 1950.12
R235 vdd.n61 vdd.n16 1950.12
R236 vdd.n31 vdd.n20 1950.12
R237 vdd.n33 vdd.n32 1950.12
R238 vdd.n34 vdd.n28 1950.12
R239 vdd.n38 vdd.n37 1950.12
R240 vdd.n40 vdd.n39 1950.12
R241 vdd.n41 vdd.n26 1950.12
R242 vdd.n45 vdd.n44 1950.12
R243 vdd.n47 vdd.n46 1950.12
R244 vdd.n48 vdd.n24 1950.12
R245 vdd.n52 vdd.n51 1950.12
R246 vdd.n53 vdd.n0 1950.12
R247 vdd.n22 vdd.n1 1949.49
R248 vdd.n5 vdd.n21 1949.49
R249 vdd.n73 vdd.n4 1949.49
R250 vdd.n72 vdd.n9 1949.49
R251 vdd.n70 vdd.n10 1949.49
R252 vdd.n69 vdd.n11 1949.49
R253 vdd.n67 vdd.n13 1949.49
R254 vdd.n66 vdd.n14 1949.49
R255 vdd.n65 vdd.n15 1949.49
R256 vdd.n62 vdd.n17 1949.49
R257 vdd.n61 vdd.n18 1949.49
R258 vdd.n29 vdd.n20 1949.49
R259 vdd.n33 vdd.n30 1949.49
R260 vdd.n35 vdd.n34 1949.49
R261 vdd.n37 vdd.n36 1949.49
R262 vdd.n40 vdd.n27 1949.49
R263 vdd.n42 vdd.n41 1949.49
R264 vdd.n44 vdd.n43 1949.49
R265 vdd.n47 vdd.n25 1949.49
R266 vdd.n49 vdd.n48 1949.49
R267 vdd.n51 vdd.n50 1949.49
R268 vdd.n53 vdd.n2 1949.49
R269 vdd.n74 vdd.n73 1523.53
R270 vdd.n72 vdd.n7 1523.53
R271 vdd.n3 vdd.t17 543.91
R272 vdd.n0 vdd.t13 543.91
R273 vdd.n1 vdd.t24 543.285
R274 vdd.n2 vdd.t21 543.285
R275 vdd.n7 vdd.t3 33.0008
R276 vdd.n71 vdd.t1 33.0008
R277 vdd.n0 vdd.t16 29.0193
R278 vdd.n3 vdd.t19 28.914
R279 vdd.n6 vdd.t20 28.914
R280 vdd.n0 vdd.t15 28.914
R281 vdd.n2 vdd.t23 28.3943
R282 vdd.n1 vdd.t26 28.289
R283 vdd.n5 vdd.t27 28.289
R284 vdd.n2 vdd.t22 28.289
R285 vdd.n54 vdd.t14 27.0607
R286 vdd.t14 vdd.n53 22.2316
R287 vdd.n51 vdd.t28 22.2316
R288 vdd.n48 vdd.t4 22.2316
R289 vdd.t29 vdd.n47 22.2316
R290 vdd.n44 vdd.t5 22.2316
R291 vdd.n41 vdd.t30 22.2316
R292 vdd.t6 vdd.n40 22.2316
R293 vdd.n37 vdd.t31 22.2316
R294 vdd.n34 vdd.t7 22.2316
R295 vdd.t32 vdd.n33 22.2316
R296 vdd.t8 vdd.n20 22.2316
R297 vdd.n61 vdd.t33 22.2316
R298 vdd.n62 vdd.t9 22.2316
R299 vdd.n65 vdd.t34 22.2316
R300 vdd.n66 vdd.t10 22.2316
R301 vdd.n67 vdd.t35 22.2316
R302 vdd.n69 vdd.t11 22.2316
R303 vdd.n70 vdd.t18 22.2316
R304 vdd.n72 vdd.t0 22.2316
R305 vdd.n73 vdd.t2 22.2316
R306 vdd.n21 vdd.t12 22.2316
R307 vdd.n22 vdd.t25 22.2316
R308 vdd.n23 vdd.n22 19.3124
R309 vdd.n53 vdd.t28 16.4385
R310 vdd.n51 vdd.t4 16.4385
R311 vdd.n48 vdd.t29 16.4385
R312 vdd.n47 vdd.t5 16.4385
R313 vdd.n44 vdd.t30 16.4385
R314 vdd.n41 vdd.t6 16.4385
R315 vdd.n40 vdd.t31 16.4385
R316 vdd.n37 vdd.t7 16.4385
R317 vdd.n34 vdd.t32 16.4385
R318 vdd.n33 vdd.t8 16.4385
R319 vdd.t9 vdd.n61 16.4385
R320 vdd.n62 vdd.t34 16.4385
R321 vdd.t10 vdd.n65 16.4385
R322 vdd.t35 vdd.n66 16.4385
R323 vdd.n67 vdd.t11 16.4385
R324 vdd.t18 vdd.n69 16.4385
R325 vdd.n70 vdd.t0 16.4385
R326 vdd.t2 vdd.n72 16.4385
R327 vdd.n73 vdd.t12 16.4385
R328 vdd.n21 vdd.t25 16.4385
R329 vdd.n56 vdd.n8 15.8709
R330 vdd.t33 vdd.n60 12.0936
R331 vdd.n60 vdd.n20 4.34534
R332 vdd vdd.n74 3.04147
R333 vdd.n1 vdd.n8 2.62317
R334 vdd vdd.n8 2.50638
R335 vdd.n60 vdd.n19 0.521627
R336 vdd.n56 vdd.n19 0.521627
R337 vdd.n60 vdd.n59 0.521627
R338 vdd.n59 vdd.n58 0.521627
R339 vdd.n57 vdd.n54 0.484793
R340 vdd.n55 vdd.n23 0.484793
R341 vdd.n50 vdd.n2 0.277213
R342 vdd.n0 vdd.n52 0.277213
R343 vdd.n7 vdd.n71 0.20965
R344 vdd.n50 vdd.n49 0.20965
R345 vdd.n49 vdd.n25 0.20965
R346 vdd.n43 vdd.n25 0.20965
R347 vdd.n43 vdd.n42 0.20965
R348 vdd.n42 vdd.n27 0.20965
R349 vdd.n36 vdd.n27 0.20965
R350 vdd.n36 vdd.n35 0.20965
R351 vdd.n35 vdd.n30 0.20965
R352 vdd.n30 vdd.n29 0.20965
R353 vdd.n29 vdd.n18 0.20965
R354 vdd.n18 vdd.n17 0.20965
R355 vdd.n17 vdd.n15 0.20965
R356 vdd.n15 vdd.n14 0.20965
R357 vdd.n14 vdd.n13 0.20965
R358 vdd.n13 vdd.n11 0.20965
R359 vdd.n11 vdd.n10 0.20965
R360 vdd.n10 vdd.n9 0.20965
R361 vdd.n9 vdd.n4 0.20965
R362 vdd.n5 vdd.n4 0.20965
R363 vdd.n52 vdd.n24 0.20965
R364 vdd.n46 vdd.n24 0.20965
R365 vdd.n46 vdd.n45 0.20965
R366 vdd.n45 vdd.n26 0.20965
R367 vdd.n39 vdd.n26 0.20965
R368 vdd.n39 vdd.n38 0.20965
R369 vdd.n38 vdd.n28 0.20965
R370 vdd.n32 vdd.n28 0.20965
R371 vdd.n32 vdd.n31 0.20965
R372 vdd.n31 vdd.n16 0.20965
R373 vdd.n63 vdd.n16 0.20965
R374 vdd.n64 vdd.n63 0.20965
R375 vdd.n64 vdd.n12 0.20965
R376 vdd.n68 vdd.n12 0.20965
R377 vdd.n6 vdd.n68 0.20965
R378 vdd.n1 vdd.n5 0.20965
R379 vdd.n74 vdd.n7 0.173421
R380 vdd.n6 vdd.n3 0.142087
R381 vdd.n71 vdd.n3 0.104292
R382 vss.n8 vss.n5 31612.7
R383 vss.n12 vss.n8 31612.7
R384 vss.n12 vss.n7 31612.7
R385 vss.n7 vss.n5 31612.7
R386 vss.n11 vss.n4 2054.02
R387 vss.n11 vss.n10 2054.02
R388 vss.n9 vss.n4 2054.02
R389 vss.n10 vss.n9 2054.02
R390 vss.n1 vss.n16 747.46
R391 vss.n15 vss.n3 747.46
R392 vss.n2 vss.n14 747.46
R393 vss.n13 vss.n0 747.46
R394 vss.t1 vss.n12 393.839
R395 vss.n13 vss.t1 320.625
R396 vss.n14 vss.t10 320.625
R397 vss.n15 vss.t8 320.625
R398 vss.n16 vss.t5 320.625
R399 vss.n16 vss.n5 295.101
R400 vss.t10 vss.n13 231.871
R401 vss.t5 vss.n15 231.871
R402 vss.n1 vss.t4 221.78
R403 vss.n0 vss.t0 221.78
R404 vss.n6 vss.t8 165.305
R405 vss.n14 vss.n6 66.5663
R406 vss.n0 vss.t3 18.8518
R407 vss.n1 vss.t6 18.7465
R408 vss.n3 vss.t7 18.7465
R409 vss.n2 vss.t9 18.7465
R410 vss.n0 vss.t11 18.7465
R411 vss.n0 vss.t2 18.7465
R412 vss vss.n4 16.3958
R413 vss.n8 vss.n6 8.60344
R414 vss.n8 vss.n4 8.60344
R415 vss.n7 vss.n6 8.60344
R416 vss.n10 vss.n7 8.60344
R417 vss.n12 vss.n11 6.64823
R418 vss.n9 vss.n5 6.64823
R419 vss vss.n1 6.35027
R420 vss.n2 vss.n0 0.256063
R421 vss.n3 vss.n2 0.19555
R422 vss.n3 vss.n1 0.19555
C0 inp out 9.61412f
C1 vdd x1 0.11559p
C2 x1 s1t 0.1192f
C3 t1 x1 28.1886f
C4 x1 inn 1.75562f
C5 vdd out 98.422f
C6 inp vdd 38.0889f
C7 out s1t 0.99866f
C8 inp s1t 0.10995f
C9 t1 out 32.1424f
C10 inp t1 79.94711f
C11 out inn 80.4399f
C12 inp inn 11.1924f
C13 vdd s1t 11.8234f
C14 x1 out 3.5982f
C15 inp x1 81.1701f
C16 vdd t1 0.23147p
C17 vdd inn 39.6908f
C18 t1 s1t 8.54662f
C19 s1t inn 0.1221f
C20 t1 inn 79.90379f
C21 s1t vss 0.78276f
C22 out vss 11.25706f
C23 inn vss 9.24907f
C24 x1 vss 22.54674f
C25 t1 vss 7.44688f
C26 inp vss 5.92097f
C27 vdd vss 1.89907p
C28 vss.t11 vss 3.50353f
C29 vss.t9 vss 3.50353f
C30 vdd.n0 vss 2.12346f
C31 vdd.n1 vss 2.366f
C32 vdd.n2 vss 2.09997f
C33 vdd.n3 vss 1.74372f
C34 vdd.n4 vss 0.65821f
C35 vdd.n5 vss 0.8848f
C36 vdd.n6 vss 0.89699f
C37 vdd.n7 vss 0.91103f
C38 vdd.n8 vss 4.88213f
C39 vdd.t3 vss 4.41769f
C40 vdd.t12 vss 9.69821f
C41 vdd.n9 vss 0.65821f
C42 vdd.t0 vss 9.69821f
C43 vdd.n10 vss 0.65821f
C44 vdd.n11 vss 0.65821f
C45 vdd.t11 vss 9.69821f
C46 vdd.t19 vss 2.24f
C47 vdd.t20 vss 2.24f
C48 vdd.n12 vss 0.66739f
C49 vdd.n13 vss 0.65821f
C50 vdd.n14 vss 0.65821f
C51 vdd.n15 vss 0.65821f
C52 vdd.t34 vss 9.69821f
C53 vdd.n16 vss 0.66739f
C54 vdd.n17 vss 0.65821f
C55 vdd.n18 vss 0.65821f
C56 vdd.n19 vss 0.5934f
C57 vdd.n20 vss 7.79444f
C58 vdd.t25 vss 9.69821f
C59 vdd.n21 vss 10.2627f
C60 vdd.t27 vss 2.2331f
C61 vdd.t26 vss 2.2331f
C62 vdd.n22 vss 11.0046f
C63 vdd.n23 vss 6.13535f
C64 vdd.t28 vss 9.69821f
C65 vdd.t23 vss 2.23423f
C66 vdd.t22 vss 2.2331f
C67 vdd.n24 vss 0.66739f
C68 vdd.t4 vss 9.69821f
C69 vdd.n25 vss 0.65821f
C70 vdd.t5 vss 9.69821f
C71 vdd.n26 vss 0.66739f
C72 vdd.t30 vss 9.69821f
C73 vdd.n27 vss 0.65821f
C74 vdd.t31 vss 9.69821f
C75 vdd.n28 vss 0.66739f
C76 vdd.t7 vss 9.69821f
C77 vdd.n29 vss 0.65821f
C78 vdd.n30 vss 0.65821f
C79 vdd.t8 vss 9.69821f
C80 vdd.n31 vss 0.66739f
C81 vdd.n32 vss 0.66739f
C82 vdd.n33 vss 10.8274f
C83 vdd.t32 vss 9.69821f
C84 vdd.n34 vss 10.8274f
C85 vdd.n35 vss 0.65821f
C86 vdd.n36 vss 0.65821f
C87 vdd.n37 vss 10.8274f
C88 vdd.n38 vss 0.66739f
C89 vdd.n39 vss 0.66739f
C90 vdd.n40 vss 10.8274f
C91 vdd.t6 vss 9.69821f
C92 vdd.n41 vss 10.8274f
C93 vdd.n42 vss 0.65821f
C94 vdd.n43 vss 0.65821f
C95 vdd.n44 vss 10.8274f
C96 vdd.n45 vss 0.66739f
C97 vdd.n46 vss 0.66739f
C98 vdd.n47 vss 10.8274f
C99 vdd.t29 vss 9.69821f
C100 vdd.n48 vss 10.8274f
C101 vdd.n49 vss 0.65821f
C102 vdd.n50 vss 0.65821f
C103 vdd.n51 vss 10.8274f
C104 vdd.n52 vss 0.66739f
C105 vdd.t16 vss 2.24111f
C106 vdd.t15 vss 2.24f
C107 vdd.n53 vss 10.8274f
C108 vdd.t14 vss 12.3773f
C109 vdd.n54 vss 8.08467f
C110 vdd.n55 vss 0.59338f
C111 vdd.n56 vss 2.52566f
C112 vdd.n57 vss 0.59338f
C113 vdd.n58 vss 1.36668f
C114 vdd.n59 vss 0.5934f
C115 vdd.n60 vss 4.12265f
C116 vdd.t33 vss 8.60852f
C117 vdd.n61 vss 10.8274f
C118 vdd.t9 vss 9.69821f
C119 vdd.n62 vss 10.8274f
C120 vdd.n63 vss 0.66739f
C121 vdd.n64 vss 0.66739f
C122 vdd.n65 vss 10.8274f
C123 vdd.t10 vss 9.69821f
C124 vdd.n66 vss 10.8274f
C125 vdd.t35 vss 9.69821f
C126 vdd.n67 vss 10.8274f
C127 vdd.n68 vss 0.66739f
C128 vdd.n69 vss 10.8274f
C129 vdd.t18 vss 9.69821f
C130 vdd.n70 vss 10.8274f
C131 vdd.t1 vss 4.41937f
C132 vdd.n71 vss 0.34668f
C133 vdd.n72 vss 10.7035f
C134 vdd.t2 vss 9.69821f
C135 vdd.n73 vss 10.7035f
C136 vdd.n74 vss 1.447f
C137 inp.n0 vss 6.50628f
C138 inp.n1 vss 3.37423f
C139 inp.n2 vss 3.37423f
C140 inp.n3 vss 3.37423f
C141 inp.n4 vss 3.37423f
C142 inp.n5 vss 3.37423f
C143 inp.n6 vss 4.55322f
C144 inp.n7 vss 6.50628f
C145 inp.n8 vss 3.37423f
C146 inp.n9 vss 3.37423f
C147 inp.n10 vss 3.37423f
C148 inp.n11 vss 3.37423f
C149 inp.n12 vss 3.37423f
C150 inp.n13 vss 3.37423f
C151 inp.n14 vss 3.37423f
C152 inp.n15 vss 4.77403f
C153 t1.t31 vss 13.24774f
C154 t1.t6 vss 13.08753f
C155 t1.n0 vss 5.50867f
C156 t1.t24 vss 13.19888f
C157 t1.n1 vss 2.93434f
C158 t1.t7 vss 13.08472f
C159 t1.n2 vss 2.93434f
C160 t1.t29 vss 13.19888f
C161 t1.n3 vss 2.93434f
C162 t1.t8 vss 13.08472f
C163 t1.n4 vss 2.93434f
C164 t1.t28 vss 13.19888f
C165 t1.n5 vss 2.93434f
C166 t1.t9 vss 13.08472f
C167 t1.n6 vss 2.93434f
C168 t1.t27 vss 13.19888f
C169 t1.n7 vss 2.93434f
C170 t1.t10 vss 13.08472f
C171 t1.n8 vss 2.93434f
C172 t1.t30 vss 13.19888f
C173 t1.n9 vss 2.93434f
C174 t1.t11 vss 13.08472f
C175 t1.n10 vss 2.93434f
C176 t1.t33 vss 13.19888f
C177 t1.n11 vss 2.93434f
C178 t1.t12 vss 13.08472f
C179 t1.n12 vss 2.93434f
C180 t1.t34 vss 13.19888f
C181 t1.n13 vss 2.93434f
C182 t1.t13 vss 13.08472f
C183 t1.n14 vss 3.4554f
C184 t1.t5 vss 10.7742f
C185 t1.n15 vss 3.59071f
C186 t1.t4 vss 10.77252f
C187 t1.n16 vss 5.64923f
C188 t1.t37 vss 13.1878f
C189 t1.t14 vss 13.02705f
C190 t1.n17 vss 5.45362f
C191 t1.t35 vss 13.1384f
C192 t1.n18 vss 2.90708f
C193 t1.t15 vss 13.02425f
C194 t1.n19 vss 2.90708f
C195 t1.t26 vss 13.1384f
C196 t1.n20 vss 2.90708f
C197 t1.t16 vss 13.02425f
C198 t1.n21 vss 2.90708f
C199 t1.t32 vss 13.1384f
C200 t1.n22 vss 2.90708f
C201 t1.t17 vss 13.02425f
C202 t1.n23 vss 2.90708f
C203 t1.t25 vss 13.1384f
C204 t1.n24 vss 2.90708f
C205 t1.t18 vss 13.02425f
C206 t1.n25 vss 2.90708f
C207 t1.t36 vss 13.1384f
C208 t1.n26 vss 2.90708f
C209 t1.t19 vss 13.02425f
C210 t1.n27 vss 2.90708f
C211 t1.t1 vss 13.1384f
C212 t1.n28 vss 2.90708f
C213 t1.t20 vss 13.02425f
C214 t1.n29 vss 2.90708f
C215 t1.t3 vss 13.1384f
C216 t1.n30 vss 2.90708f
C217 t1.t21 vss 13.02425f
C218 t1.n31 vss 2.90708f
C219 t1.t2 vss 13.1384f
C220 t1.n32 vss 2.90708f
C221 t1.t22 vss 13.02425f
C222 t1.n33 vss 2.90708f
C223 t1.t0 vss 13.1384f
C224 t1.n34 vss 2.90708f
C225 t1.t23 vss 13.02425f
C226 t1.n35 vss 7.74402f
C227 x1.t11 vss 11.3151f
C228 x1.t4 vss 11.23602f
C229 x1.n0 vss 5.09035f
C230 x1.t9 vss 11.23602f
C231 x1.n1 vss 2.83648f
C232 x1.t8 vss 11.23602f
C233 x1.n2 vss 2.83648f
C234 x1.t7 vss 11.23602f
C235 x1.n3 vss 2.83648f
C236 x1.t10 vss 11.23602f
C237 x1.n4 vss 2.83648f
C238 x1.t13 vss 11.23602f
C239 x1.n5 vss 2.83648f
C240 x1.t14 vss 11.23602f
C241 x1.n6 vss 5.99616f
C242 x1.t17 vss 5.89909f
C243 x1.n7 vss 3.71116f
C244 x1.n8 vss 12.8454f
C245 x1.t19 vss 11.27091f
C246 x1.t15 vss 11.191f
C247 x1.n9 vss 5.04504f
C248 x1.t6 vss 11.191f
C249 x1.n10 vss 2.81425f
C250 x1.t12 vss 11.191f
C251 x1.n11 vss 2.81425f
C252 x1.t5 vss 11.191f
C253 x1.n12 vss 2.81425f
C254 x1.t18 vss 11.191f
C255 x1.n13 vss 2.81425f
C256 x1.t1 vss 11.191f
C257 x1.n14 vss 2.81425f
C258 x1.t3 vss 11.191f
C259 x1.n15 vss 2.81425f
C260 x1.t2 vss 11.191f
C261 x1.n16 vss 2.81425f
C262 x1.t0 vss 11.191f
C263 x1.n17 vss 4.68103f
C264 x1.n18 vss 13.2968f
C265 inn.n0 vss 6.28153f
C266 inn.n1 vss 3.25865f
C267 inn.n2 vss 3.25865f
C268 inn.n3 vss 3.25865f
C269 inn.n4 vss 3.25865f
C270 inn.n5 vss 3.25865f
C271 inn.n6 vss 4.19041f
C272 inn.n7 vss 6.28153f
C273 inn.n8 vss 3.25865f
C274 inn.n9 vss 3.25865f
C275 inn.n10 vss 3.25865f
C276 inn.n11 vss 3.25865f
C277 inn.n12 vss 3.25865f
C278 inn.n13 vss 3.25865f
C279 inn.n14 vss 3.25865f
C280 inn.n15 vss 4.37088f
C281 out.t9 vss 11.76081f
C282 out.t16 vss 11.66854f
C283 out.n0 vss 5.44143f
C284 out.t3 vss 11.66854f
C285 out.n1 vss 3.04706f
C286 out.t11 vss 11.66854f
C287 out.n2 vss 3.04706f
C288 out.t2 vss 11.66854f
C289 out.n3 vss 3.04706f
C290 out.t18 vss 11.66854f
C291 out.n4 vss 3.04706f
C292 out.t13 vss 11.66854f
C293 out.n5 vss 3.04706f
C294 out.t6 vss 11.66854f
C295 out.n6 vss 5.73429f
C296 out.t1 vss 12.391f
C297 out.t12 vss 11.76081f
C298 out.t8 vss 11.66854f
C299 out.n7 vss 5.44143f
C300 out.t5 vss 11.66854f
C301 out.n8 vss 3.04706f
C302 out.t4 vss 11.66854f
C303 out.n9 vss 3.04706f
C304 out.t0 vss 11.66854f
C305 out.n10 vss 3.04706f
C306 out.t7 vss 11.66854f
C307 out.n11 vss 3.04706f
C308 out.t17 vss 11.66854f
C309 out.n12 vss 3.04706f
C310 out.t10 vss 11.66854f
C311 out.n13 vss 3.04706f
C312 out.t14 vss 11.66854f
C313 out.n14 vss 3.04706f
C314 out.t15 vss 11.66854f
C315 out.n15 vss 4.18621f
C316 out.n16 vss 19.2756f
C317 s1t.n0 vss 6.82285f
.ends
