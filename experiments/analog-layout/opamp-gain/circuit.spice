** sch_path: /home/cgao/.codex/worktrees/analog-layout-loop/ChipJev/runs/validated-opamp-gain/circuit.sch
**.subckt circuit
VDD vdd 0 1.8
XM1 t1 s1t vdd vdd sky130_fd_pr__pfet_01v8 L=0.25 W=6.06 nf=1 ad=1.7574 as=1.7574 pd=12.7 ps=12.7 nrd=0.0478548 nrs=0.0478548 sa=0
+ sb=0 sd=0 mult=1
XM2 x1 inp t1 vdd sky130_fd_pr__pfet_01v8 L=0.25 W=2.21 nf=1 ad=0.6409 as=0.6409 pd=5 ps=5 nrd=0.131222 nrs=0.131222 sa=0 sb=0
+ sd=0 mult=1
XM3 x2 inn t1 vdd sky130_fd_pr__pfet_01v8 L=0.25 W=2.21 nf=1 ad=0.6409 as=0.6409 pd=5 ps=5 nrd=0.131222 nrs=0.131222 sa=0 sb=0
+ sd=0 mult=1
XM4 x1 x1 0 0 sky130_fd_pr__nfet_01v8 L=0.25 W=25.74 nf=1 ad=7.4646 as=7.4646 pd=52.06 ps=52.06 nrd=0.0112665 nrs=0.0112665 sa=0
+ sb=0 sd=0 mult=1
XM5 x2 x2 0 0 sky130_fd_pr__nfet_01v8 L=0.25 W=25.74 nf=1 ad=7.4646 as=7.4646 pd=52.06 ps=52.06 nrd=0.0112665 nrs=0.0112665 sa=0
+ sb=0 sd=0 mult=1
XM6 y1 x2 0 0 sky130_fd_pr__nfet_01v8 L=0.25 W=109.26 nf=3 ad=21.1236 as=21.1236 pd=146.84 ps=146.84 nrd=0.00265422 nrs=0.00265422
+ sa=0 sb=0 sd=0 mult=1
XM7 o1 x1 0 0 sky130_fd_pr__nfet_01v8 L=0.25 W=109.26 nf=3 ad=21.1236 as=21.1236 pd=146.84 ps=146.84 nrd=0.00265422 nrs=0.00265422
+ sa=0 sb=0 sd=0 mult=1
XM8 y1 y1 vdd vdd sky130_fd_pr__pfet_01v8 L=0.25 W=22.28 nf=1 ad=6.4612 as=6.4612 pd=45.14 ps=45.14 nrd=0.0130162 nrs=0.0130162
+ sa=0 sb=0 sd=0 mult=1
XM9 o1 y1 vdd vdd sky130_fd_pr__pfet_01v8 L=0.25 W=22.28 nf=1 ad=6.4612 as=6.4612 pd=45.14 ps=45.14 nrd=0.0130162 nrs=0.0130162
+ sa=0 sb=0 sd=0 mult=1
XM10 s2a o1 0 0 sky130_fd_pr__nfet_01v8 L=0.18 W=3.71 nf=1 ad=1.0759 as=1.0759 pd=8 ps=8 nrd=0.0781671 nrs=0.0781671 sa=0 sb=0
+ sd=0 mult=1
XM11 out s2cn s2a 0 sky130_fd_pr__nfet_01v8 L=0.18 W=4.28 nf=1 ad=1.2412 as=1.2412 pd=9.14 ps=9.14 nrd=0.067757 nrs=0.067757 sa=0
+ sb=0 sd=0 mult=1
XM12 out s2cp s2c vdd sky130_fd_pr__pfet_01v8 L=0.18 W=4.28 nf=1 ad=1.2412 as=1.2412 pd=9.14 ps=9.14 nrd=0.067757 nrs=0.067757
+ sa=0 sb=0 sd=0 mult=1
XM13 s2c o1 vdd vdd sky130_fd_pr__pfet_01v8 L=0.18 W=4.28 nf=1 ad=1.2412 as=1.2412 pd=9.14 ps=9.14 nrd=0.067757 nrs=0.067757 sa=0
+ sb=0 sd=0 mult=1
V_S1T s1t 0 0.7325
V_S2CN s2cn 0 0.98
V_S2CP s2cp 0 0.435
**.ends
.end
