* NGSPICE file created from layout.ext - technology: sky130A

.subckt layout inn inp o1 out s1t s2a s2c s2cn s2cp t1 vdd vss x1 x2 y1
X0 o1.t3 x1.t4 vss.t21 vss.t20 sky130_fd_pr__nfet_01v8 ad=10.5618 pd=73.42 as=10.5618 ps=73.42 w=36.42 l=0.25
X1 x1.t2 inp.t0 t1.t0 vdd.t16 sky130_fd_pr__pfet_01v8 ad=0.6409 pd=5 as=0.6409 ps=5 w=2.21 l=0.25
X2 o1.t0 y1.t5 vdd.t21 vdd.t20 sky130_fd_pr__pfet_01v8 ad=6.4612 pd=45.14 as=6.4612 ps=45.14 w=22.28 l=0.25
X3 y1.t4 y1.t3 vdd.t23 vdd.t22 sky130_fd_pr__pfet_01v8 ad=6.4612 pd=45.14 as=6.4612 ps=45.14 w=22.28 l=0.25
X4 s2c.t1 o1.t5 vdd.t19 vdd.t18 sky130_fd_pr__pfet_01v8 ad=1.2412 pd=9.14 as=1.2412 ps=9.14 w=4.28 l=0.18
X5 vdd.t3 vdd.t0 vdd.t2 vdd.t1 sky130_fd_pr__pfet_01v8 ad=0.6409 pd=5 as=0 ps=0 w=2.21 l=0.25
X6 x2.t2 x2.t1 vss.t1 vss.t0 sky130_fd_pr__nfet_01v8 ad=7.4646 pd=52.06 as=7.4646 ps=52.06 w=25.74 l=0.25
X7 y1.t1 x2.t4 vss.t5 vss.t4 sky130_fd_pr__nfet_01v8 ad=10.5618 pd=73.42 as=10.5618 ps=73.42 w=36.42 l=0.25
X8 vss.t11 vss.t8 vss.t10 vss.t9 sky130_fd_pr__nfet_01v8 ad=7.4646 pd=52.06 as=0 ps=0 w=25.74 l=0.25
X9 vdd.t15 vdd.t12 vdd.t14 vdd.t13 sky130_fd_pr__pfet_01v8 ad=6.4612 pd=45.14 as=0 ps=0 w=22.28 l=0.25
X10 vdd.t7 vdd.t4 vdd.t6 vdd.t5 sky130_fd_pr__pfet_01v8 ad=0.6409 pd=5 as=0 ps=0 w=2.21 l=0.25
X11 t1.t2 s1t.t0 vdd.t26 vdd.t25 sky130_fd_pr__pfet_01v8 ad=1.7574 pd=12.7 as=1.7574 ps=12.7 w=6.06 l=0.25
X12 y1.t2 x2.t5 vss.t3 vss.t2 sky130_fd_pr__nfet_01v8 ad=10.5618 pd=73.42 as=10.5618 ps=73.42 w=36.42 l=0.25
X13 y1.t0 x2.t3 vss.t7 vss.t6 sky130_fd_pr__nfet_01v8 ad=10.5618 pd=73.42 as=10.5618 ps=73.42 w=36.42 l=0.25
X14 x2.t0 inn.t0 t1.t1 vdd.t24 sky130_fd_pr__pfet_01v8 ad=0.6409 pd=5 as=0.6409 ps=5 w=2.21 l=0.25
X15 o1.t2 x1.t5 vss.t19 vss.t18 sky130_fd_pr__nfet_01v8 ad=10.5618 pd=73.42 as=10.5618 ps=73.42 w=36.42 l=0.25
X16 o1.t1 x1.t3 vss.t23 vss.t22 sky130_fd_pr__nfet_01v8 ad=10.5618 pd=73.42 as=10.5618 ps=73.42 w=36.42 l=0.25
X17 s2a.t1 o1.t4 vss.t25 vss.t24 sky130_fd_pr__nfet_01v8 ad=1.0759 pd=8 as=1.0759 ps=8 w=3.71 l=0.18
X18 vdd.t11 vdd.t8 vdd.t10 vdd.t9 sky130_fd_pr__pfet_01v8 ad=6.4612 pd=45.14 as=0 ps=0 w=22.28 l=0.25
X19 out.t0 s2cp.t0 s2c.t0 vdd.t17 sky130_fd_pr__pfet_01v8 ad=1.2412 pd=9.14 as=1.2412 ps=9.14 w=4.28 l=0.18
X20 x1.t1 x1.t0 vss.t17 vss.t16 sky130_fd_pr__nfet_01v8 ad=7.4646 pd=52.06 as=7.4646 ps=52.06 w=25.74 l=0.25
X21 vss.t15 vss.t12 vss.t14 vss.t13 sky130_fd_pr__nfet_01v8 ad=7.4646 pd=52.06 as=0 ps=0 w=25.74 l=0.25
X22 out.t1 s2cn.t0 s2a.t0 vss.t26 sky130_fd_pr__nfet_01v8 ad=1.2412 pd=9.14 as=1.2412 ps=9.14 w=4.28 l=0.18
R0 s2a.n0 s2a.t1 49.4847
R1 s2a.n0 s2a.t0 46.9447
R2 s2a s2a.n0 5.47004
R3 s2cn s2cn.t0 820.456
R4 out out.t0 81.9272
R5 out out.t1 56.1165
R6 s2c.n0 s2c.t0 78.3365
R7 s2c.n0 s2c.t1 77.9925
R8 s2c s2c.n0 5.56216
R9 s2cp s2cp.t0 828.106
R10 s1t s1t.t0 824.928
R11 o1.n0 o1.t5 819.399
R12 o1.n3 o1.t4 736.75
R13 o1.n0 o1.t0 27.3222
R14 o1.n1 o1.t2 20.2765
R15 o1.n2 o1.t1 20.0105
R16 o1.n1 o1.t3 20.0105
R17 o1 o1.n3 9.74892
R18 o1 o1.n0 4.55401
R19 o1.n3 o1.n2 0.34877
R20 o1.n2 o1.n1 0.26652
R21 y1.n1 y1.t5 2379.85
R22 y1.n0 y1.t3 2379.85
R23 y1.n0 y1.t4 32.0909
R24 y1.n2 y1.t2 24.988
R25 y1.n3 y1.t0 24.722
R26 y1.n2 y1.t1 24.722
R27 y1 y1.n3 13.3957
R28 y1 y1.n1 8.00287
R29 y1.n1 y1.n0 0.30036
R30 y1.n3 y1.n2 0.26652
R31 x2.n3 x2.t3 3731.04
R32 x2.n2 x2.t4 3731.04
R33 x2.n1 x2.t5 3731.04
R34 x2.n0 x2.t1 2706.62
R35 x2 x2.t0 146.81
R36 x2.n0 x2.t2 27.728
R37 x2 x2.n3 13.0812
R38 x2.n1 x2.n0 0.53254
R39 x2.n2 x2.n1 0.26652
R40 x2.n3 x2.n2 0.26652
R41 inn inn.t0 454.036
R42 x1.n3 x1.t3 3730.42
R43 x1.n2 x1.t4 3730.42
R44 x1.n1 x1.t5 3730.42
R45 x1.n0 x1.t0 2706
R46 x1 x1.t2 146.26
R47 x1.n0 x1.t1 27.103
R48 x1 x1.n3 12.0576
R49 x1.n1 x1.n0 1.59662
R50 x1.n2 x1.n1 0.26652
R51 x1.n3 x1.n2 0.26652
R52 t1.n0 t1.t0 135.816
R53 t1.n0 t1.t1 135.517
R54 t1.n1 t1.t2 62.288
R55 t1 t1.n1 6.8321
R56 t1.n1 t1.n0 1.85042
R57 inp inp.t0 455.187
R58 vdd.n12 vdd.n9 30261.2
R59 vdd.n16 vdd.n12 30261.2
R60 vdd.n16 vdd.n11 30261.2
R61 vdd.n11 vdd.n9 30261.2
R62 vdd.n15 vdd.n8 3227.86
R63 vdd.n15 vdd.n14 3227.86
R64 vdd.n13 vdd.n8 3227.86
R65 vdd.n14 vdd.n13 3227.86
R66 vdd.n2 vdd.t12 2377.81
R67 vdd.n3 vdd.t8 2377.81
R68 vdd.n24 vdd.n2 903.003
R69 vdd.n0 vdd.n23 903.003
R70 vdd.n22 vdd.n0 903.003
R71 vdd.n3 vdd.n21 903.003
R72 vdd.n7 vdd.t4 452.709
R73 vdd.n1 vdd.t0 452.709
R74 vdd.n26 vdd.n25 305.426
R75 vdd.n29 vdd.n28 244.582
R76 vdd.n27 vdd.n5 244.582
R77 vdd.n20 vdd.n7 183.096
R78 vdd.n4 vdd.n19 183.096
R79 vdd.n18 vdd.n6 183.096
R80 vdd.n17 vdd.n1 183.096
R81 vdd.n1 vdd.t3 136.331
R82 vdd.n4 vdd.t6 136.31
R83 vdd.n4 vdd.t7 136.31
R84 vdd.n1 vdd.t2 136.31
R85 vdd.n5 vdd.t19 80.0357
R86 vdd.n2 vdd.t26 63.0813
R87 vdd.n28 vdd.n9 53.4485
R88 vdd.t1 vdd.n16 53.3483
R89 vdd.n17 vdd.t1 39.9678
R90 vdd.n18 vdd.t16 39.9678
R91 vdd.n19 vdd.t24 39.9678
R92 vdd.n20 vdd.t5 39.9678
R93 vdd.n21 vdd.t9 39.9678
R94 vdd.n23 vdd.t20 39.9678
R95 vdd.n24 vdd.t13 39.9678
R96 vdd.n25 vdd.t25 39.9678
R97 vdd.n27 vdd.t17 39.2666
R98 vdd.n28 vdd.t18 39.2666
R99 vdd.n2 vdd.t14 29.9418
R100 vdd.n2 vdd.t15 29.9418
R101 vdd.n0 vdd.t21 29.9418
R102 vdd.n3 vdd.t23 29.9418
R103 vdd.n3 vdd.t10 29.9418
R104 vdd.n3 vdd.t11 29.9418
R105 vdd.t18 vdd.n27 24.642
R106 vdd.t16 vdd.n17 23.9408
R107 vdd.t24 vdd.n18 23.9408
R108 vdd.n19 vdd.t5 23.9408
R109 vdd.t9 vdd.n20 23.9408
R110 vdd.n21 vdd.t22 23.9408
R111 vdd.t20 vdd.n22 23.9408
R112 vdd.n23 vdd.t13 23.9408
R113 vdd.t25 vdd.n24 23.9408
R114 vdd.n25 vdd.t17 23.2396
R115 vdd.n22 vdd.n10 20.6353
R116 vdd.t22 vdd.n10 19.3331
R117 vdd vdd.n8 14.0956
R118 vdd vdd.n29 3.28117
R119 vdd.n12 vdd.n10 1.65229
R120 vdd.n12 vdd.n8 1.65229
R121 vdd.n11 vdd.n10 1.65229
R122 vdd.n14 vdd.n11 1.65229
R123 vdd.n16 vdd.n15 1.36079
R124 vdd.n13 vdd.n9 1.36079
R125 vdd.n1 vdd.n6 0.193004
R126 vdd.n2 vdd.n0 0.190654
R127 vdd.n7 vdd.n3 0.161671
R128 vdd.n26 vdd.n2 0.148942
R129 vdd.n4 vdd.n6 0.125442
R130 vdd.n0 vdd.n3 0.125442
R131 vdd.n29 vdd.n5 0.125442
R132 vdd.n7 vdd.n4 0.125442
R133 vdd.n5 vdd.n26 0.1227
R134 vss.n12 vss.n11 54064.9
R135 vss.n18 vss.n12 54064.9
R136 vss.n22 vss.n18 54064.9
R137 vss.n22 vss.n11 54064.9
R138 vss.n20 vss.n10 3512.85
R139 vss.n21 vss.n20 3512.85
R140 vss.n19 vss.n10 3512.85
R141 vss.n21 vss.n19 3512.85
R142 vss.n2 vss.t12 2705.21
R143 vss.n1 vss.t8 2705.21
R144 vss.n27 vss.n9 1435.77
R145 vss.n3 vss.n26 1435.77
R146 vss.n25 vss.n3 1435.77
R147 vss.n7 vss.n24 1435.77
R148 vss.n4 vss.n6 1435.77
R149 vss.n13 vss.n5 1435.77
R150 vss.n2 vss.n14 1038.16
R151 vss.n15 vss.n0 1038.16
R152 vss.n0 vss.n16 1038.16
R153 vss.n17 vss.n1 1038.16
R154 vss.n30 vss.n29 298.634
R155 vss.n28 vss.n8 283.603
R156 vss.n29 vss.n11 181.163
R157 vss.n18 vss.t9 168.531
R158 vss.t9 vss.n17 123.93
R159 vss.n16 vss.t16 123.93
R160 vss.t0 vss.n15 123.93
R161 vss.n14 vss.t13 123.93
R162 vss.t2 vss.n13 123.93
R163 vss.t4 vss.n6 123.93
R164 vss.n24 vss.t6 123.93
R165 vss.n25 vss.t18 123.93
R166 vss.n26 vss.t20 123.93
R167 vss.n27 vss.t22 123.93
R168 vss.n28 vss.t24 121.54
R169 vss.n29 vss.t26 121.54
R170 vss.t26 vss.n28 71.6951
R171 vss.n17 vss.t16 69.3053
R172 vss.n16 vss.t0 69.3053
R173 vss.n15 vss.t13 69.3053
R174 vss.n14 vss.t2 69.3053
R175 vss.n13 vss.t4 69.3053
R176 vss.n24 vss.t18 69.3053
R177 vss.t20 vss.n25 69.3053
R178 vss.n26 vss.t22 69.3053
R179 vss.t24 vss.n27 66.9155
R180 vss.n9 vss.t25 50.6811
R181 vss.n23 vss.n6 38.579
R182 vss.t6 vss.n23 30.7268
R183 vss.n1 vss.t11 26.242
R184 vss.n2 vss.t14 26.2209
R185 vss.n2 vss.t15 26.2209
R186 vss.n0 vss.t1 26.2209
R187 vss.n1 vss.t17 26.2209
R188 vss.n1 vss.t10 26.2209
R189 vss.n3 vss.t23 22.6787
R190 vss.n3 vss.t21 22.6787
R191 vss.n7 vss.t19 22.6787
R192 vss.n4 vss.t7 22.6787
R193 vss.n5 vss.t5 22.6787
R194 vss.n2 vss.t3 22.6787
R195 vss vss.n10 14.367
R196 vss.n23 vss.n12 5.36747
R197 vss.n12 vss.n10 5.36747
R198 vss.n23 vss.n22 5.36747
R199 vss.n22 vss.n21 5.36747
R200 vss.n20 vss.n18 3.63404
R201 vss.n19 vss.n11 3.63404
R202 vss vss.n30 3.23143
R203 vss.n1 vss.n0 0.282696
R204 vss.n9 vss.n3 0.193004
R205 vss.n0 vss.n2 0.140521
R206 vss.n30 vss.n8 0.111342
R207 vss.n3 vss.n7 0.111342
R208 vss.n7 vss.n4 0.111342
R209 vss.n5 vss.n4 0.111342
R210 vss.n5 vss.n2 0.111342
R211 vss.n9 vss.n8 0.1086
C0 y1 s2cn 0
C1 o1 s2a 1.30815f
C2 s1t s2cp 0.05866f
C3 vdd inp 3.58913f
C4 s2c inp 0.10207f
C5 inn vdd 3.68182f
C6 inn s2c 0.1148f
C7 y1 x1 0.51777f
C8 s2cp inp 0.05455f
C9 s2a s2cn 0.82503f
C10 inn s2cp 0.06091f
C11 y1 out 0.116f
C12 s2c vdd 4.41473f
C13 x1 s2a 0.00264f
C14 y1 t1 0.18399f
C15 s2cp vdd 2.17497f
C16 s2c s2cp 0.98157f
C17 s2a out 2.87798f
C18 s1t y1 0
C19 y1 inp 0.17774f
C20 x2 o1 0.10979f
C21 inn y1 0.20656f
C22 x2 s2cn 0
C23 y1 vdd 10.5728f
C24 y1 s2c 0
C25 x2 x1 5.21662f
C26 o1 s2cn 0.17253f
C27 y1 s2cp 0
C28 o1 x1 3.0804f
C29 x2 out 0.10837f
C30 o1 out 2.16642f
C31 x2 t1 1.64297f
C32 x1 s2cn 0.00111f
C33 o1 t1 0.10315f
C34 out s2cn 1.20181f
C35 x1 out 0.10873f
C36 x1 t1 1.67235f
C37 t1 out 0.00126f
C38 s1t o1 0.08968f
C39 x2 inp 0.06911f
C40 x2 inn 0.59487f
C41 o1 inp 0.86535f
C42 inn o1 0.12718f
C43 y1 s2a 0
C44 s1t x1 0
C45 x2 vdd 2.46007f
C46 x2 s2c 0
C47 o1 vdd 7.12942f
C48 o1 s2c 0.73195f
C49 s1t out 0.60519f
C50 x1 inp 0.62277f
C51 x2 s2cp 0
C52 inn x1 0
C53 o1 s2cp 0.06119f
C54 s1t t1 0.72436f
C55 out inp 0.05316f
C56 inn out 0.05879f
C57 x1 vdd 4.14659f
C58 s2c x1 0
C59 t1 inp 0.25676f
C60 inn t1 0.12707f
C61 out vdd 1.28467f
C62 s2c out 1.7295f
C63 x1 s2cp 0.00548f
C64 t1 vdd 9.85258f
C65 s2c t1 0.06362f
C66 s2cp out 0.70802f
C67 s2cp t1 0.94239f
C68 s1t inp 0.05488f
C69 inn s1t 0.06107f
C70 x2 y1 8.33361f
C71 o1 y1 0.83414f
C72 inn inp 1.04039f
C73 s1t vdd 2.18633f
C74 s1t s2c 0.81219f
C75 x2 s2a 0
C76 s2a vss 6.21608f
C77 s2cn vss 6.04713f
C78 out vss 13.19329f
C79 s2c vss 1.18238f
C80 s2cp vss 5.49386f
C81 s1t vss 4.68113f
C82 o1 vss 28.03075f
C83 y1 vss 30.75714f
C84 x2 vss 23.02784f
C85 inn vss 6.4848f
C86 x1 vss 25.10836f
C87 t1 vss 1.73501f
C88 inp vss 6.93609f
C89 vdd vss 0.24308p
C90 vss.t25 vss 0.0358f
C91 vss.t21 vss 0.30723f
C92 vss.t7 vss 0.3675f
C93 vss.t1 vss 0.26338f
C94 vss.t3 vss 0.3675f
C95 vss.t5 vss 0.3675f
C96 vss.t17 vss 0.22014f
C97 vss.t19 vss 0.30723f
C98 vss.t23 vss 0.30723f
C99 vdd.n0 vss 0.69041f
C100 vdd.n1 vss 0.83708f
C101 vdd.n2 vss 0.9155f
C102 vdd.n3 vss 0.8975f
C103 vdd.n4 vss 0.63566f
C104 vdd.n5 vss 0.45418f
C105 vdd.n6 vss 0.26252f
C106 vdd.n7 vss 0.40592f
C107 vdd.n8 vss 0.82367f
C108 vdd.t19 vss 0.0944f
C109 vdd.n9 vss 1.60339f
C110 vdd.t17 vss 1.48963f
C111 vdd.t26 vss 0.25073f
C112 vdd.t13 vss 1.52305f
C113 vdd.t21 vss 0.48485f
C114 vdd.n10 vss 0.9525f
C115 vdd.t22 vss 1.03128f
C116 vdd.t5 vss 1.52305f
C117 vdd.t10 vss 0.32693f
C118 vdd.t11 vss 0.32693f
C119 vdd.n11 vss 0.14707f
C120 vdd.n12 vss 0.14707f
C121 vdd.n13 vss 0.14702f
C122 vdd.n14 vss 0.32756f
C123 vdd.n15 vss 0.14702f
C124 vdd.n16 vss 1.60099f
C125 vdd.t1 vss 2.22951f
C126 vdd.t3 vss 0.03908f
C127 vdd.t2 vss 0.03905f
C128 vdd.n17 vss 1.55835f
C129 vdd.t16 vss 1.52305f
C130 vdd.n18 vss 1.55835f
C131 vdd.t24 vss 1.52305f
C132 vdd.n19 vss 1.55835f
C133 vdd.t7 vss 0.03905f
C134 vdd.t6 vss 0.03905f
C135 vdd.n20 vss 1.55835f
C136 vdd.t9 vss 1.52305f
C137 vdd.n21 vss 1.71195f
C138 vdd.t23 vss 0.48485f
C139 vdd.n22 vss 1.25122f
C140 vdd.t20 vss 1.52305f
C141 vdd.n23 vss 1.71195f
C142 vdd.t15 vss 0.32693f
C143 vdd.t14 vss 0.32693f
C144 vdd.n24 vss 1.71195f
C145 vdd.t25 vss 1.52305f
C146 vdd.n25 vss 1.56895f
C147 vdd.n26 vss 0.2573f
C148 vdd.n27 vss 1.57275f
C149 vdd.t18 vss 1.52305f
C150 vdd.n28 vss 2.26489f
C151 vdd.n29 vss 0.96378f
C152 t1.t0 vss 0.5036f
C153 t1.t1 vss 0.48979f
C154 t1.n0 vss 5.94366f
C155 t1.t2 vss 1.14976f
C156 t1.n1 vss 6.70065f
C157 x1.t2 vss 0.44106f
C158 x1.t1 vss 1.97934f
C159 x1.n0 vss 1.62168f
C160 x1.n1 vss 0.88789f
C161 x1.n2 vss 0.57769f
C162 x1.n3 vss 2.44652f
C163 x2.t0 vss 0.49607f
C164 x2.t2 vss 2.38713f
C165 x2.n0 vss 1.69352f
C166 x2.n1 vss 0.80041f
C167 x2.n2 vss 0.72621f
C168 x2.n3 vss 3.32922f
C169 y1.t4 vss 1.56062f
C170 y1.n0 vss 1.47612f
C171 y1.n1 vss 2.27258f
C172 y1.t2 vss 2.87443f
C173 y1.t1 vss 2.8677f
C174 y1.n2 vss 1.31071f
C175 y1.t0 vss 2.8677f
C176 y1.n3 vss 3.07362f
C177 o1.t0 vss 1.43155f
C178 o1.n0 vss 2.35361f
C179 o1.t2 vss 2.6811f
C180 o1.t3 vss 2.67401f
C181 o1.n1 vss 1.12753f
C182 o1.t1 vss 2.67401f
C183 o1.n2 vss 0.61455f
C184 o1.n3 vss 2.26477f
C185 s2c.t0 vss 0.79052f
C186 s2c.t1 vss 0.71726f
C187 s2c.n0 vss 6.93405f
C188 out.t0 vss 0.67229f
C189 out.t1 vss 1.47964f
C190 s2a.t1 vss 0.62626f
C191 s2a.t0 vss 0.6853f
C192 s2a.n0 vss 3.47867f
.ends
