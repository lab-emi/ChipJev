** sch_path: /home/cgao/git/ChipJev-Dev/experiments/topo-v4/xschem/sky130-amp1-gbw.sch
**.subckt sky130-amp1-gbw
XM1 out in 0 0 sky130_fd_pr__nfet_01v8 L=1.42667 W=713.333 nf=15 ad=110.329 as=110.329 pd=765.529 ps=765.529 nrd=0.000406542
+ nrs=0.000406542 sa=0 sb=0 sd=0 mult=1
XM2 out s1ld vdd vdd sky130_fd_pr__pfet_01v8 L=1.42667 W=713.333 nf=15 ad=110.329 as=110.329 pd=765.529 ps=765.529 nrd=0.000406542
+ nrs=0.000406542 sa=0 sb=0 sd=0 mult=1
VDD vdd 0 1.8
V_S1LD s1ld 0 0.05
**.ends
.end
