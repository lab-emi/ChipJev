* NGSPICE file created from layout.ext - technology: sky130A

.subckt layout inn inp o1 out s1t s2a s2c s2cn s2cp t1 vdd vss x1 x2 y1
X0 x1.t0 inp.t0 t1.t2 vdd.t3 sky130_fd_pr__pfet_01v8 ad=0.6409 pd=5 as=0.6409 ps=5 w=2.21 l=0.25
X1 y1.t0 x2.t3 vss.t7 vss.t6 sky130_fd_pr__nfet_01v8 ad=10.5618 pd=73.42 as=10.5618 ps=73.42 w=36.42 l=0.25
X2 y1.t4 y1.t3 vdd.t5 vdd.t4 sky130_fd_pr__pfet_01v8 ad=6.4612 pd=45.14 as=6.4612 ps=45.14 w=22.28 l=0.25
X3 x1.t2 x1.t1 vss.t9 vss.t8 sky130_fd_pr__nfet_01v8 ad=7.4646 pd=52.06 as=7.4646 ps=52.06 w=25.74 l=0.25
X4 out.t1 s2cp.t0 s2c.t0 vdd.t8 sky130_fd_pr__pfet_01v8 ad=1.2412 pd=9.14 as=1.2412 ps=9.14 w=4.28 l=0.18
X5 x2.t0 inn.t0 t1.t1 vdd.t0 sky130_fd_pr__pfet_01v8 ad=0.6409 pd=5 as=0.6409 ps=5 w=2.21 l=0.25
X6 o1.t2 x1.t4 vss.t13 vss.t12 sky130_fd_pr__nfet_01v8 ad=10.5618 pd=73.42 as=10.5618 ps=73.42 w=36.42 l=0.25
X7 y1.t2 x2.t5 vss.t1 vss.t0 sky130_fd_pr__nfet_01v8 ad=10.5618 pd=73.42 as=10.5618 ps=73.42 w=36.42 l=0.25
X8 s2a.t0 o1.t5 vss.t18 vss.t17 sky130_fd_pr__nfet_01v8 ad=1.0759 pd=8 as=1.0759 ps=8 w=3.71 l=0.18
X9 out.t0 s2cn.t0 s2a.t1 vss.t16 sky130_fd_pr__nfet_01v8 ad=1.2412 pd=9.14 as=1.2412 ps=9.14 w=4.28 l=0.18
X10 y1.t1 x2.t4 vss.t5 vss.t4 sky130_fd_pr__nfet_01v8 ad=10.5618 pd=73.42 as=10.5618 ps=73.42 w=36.42 l=0.25
X11 x2.t2 x2.t1 vss.t3 vss.t2 sky130_fd_pr__nfet_01v8 ad=7.4646 pd=52.06 as=7.4646 ps=52.06 w=25.74 l=0.25
X12 s2c.t1 o1.t4 vdd.t10 vdd.t9 sky130_fd_pr__pfet_01v8 ad=1.2412 pd=9.14 as=1.2412 ps=9.14 w=4.28 l=0.18
X13 o1.t3 x1.t5 vss.t11 vss.t10 sky130_fd_pr__nfet_01v8 ad=10.5618 pd=73.42 as=10.5618 ps=73.42 w=36.42 l=0.25
X14 o1.t1 x1.t3 vss.t15 vss.t14 sky130_fd_pr__nfet_01v8 ad=10.5618 pd=73.42 as=10.5618 ps=73.42 w=36.42 l=0.25
X15 o1.t0 y1.t5 vdd.t7 vdd.t6 sky130_fd_pr__pfet_01v8 ad=6.4612 pd=45.14 as=6.4612 ps=45.14 w=22.28 l=0.25
X16 t1.t0 s1t.t0 vdd.t2 vdd.t1 sky130_fd_pr__pfet_01v8 ad=1.7574 pd=12.7 as=1.7574 ps=12.7 w=6.06 l=0.25
R0 s2c s2c.t1 86.0369
R1 s2c s2c.t0 85.4155
R2 s2cp s2cp.t0 829.937
R3 out out.t1 84.5504
R4 out out.t0 48.0313
R5 s2cn s2cn.t0 817.428
R6 s2a s2a.t0 51.3109
R7 s2a s2a.t1 49.5258
R8 o1.n0 o1.t4 828.783
R9 o1.n0 o1.t5 738.981
R10 o1.n1 o1.t0 33.3986
R11 o1.n2 o1.t1 21.8662
R12 o1.n3 o1.t2 21.8662
R13 o1 o1.t3 21.8662
R14 o1.n2 o1.n1 1.16798
R15 o1.n1 o1.n0 0.73135
R16 o1 o1.n3 0.58424
R17 o1.n3 o1.n2 0.58424
R18 y1.n0 y1.t5 2387.9
R19 y1.n0 y1.t3 2387.31
R20 y1.n1 y1.t4 39.1678
R21 y1.n2 y1.t0 27.6355
R22 y1.n3 y1.t1 27.6355
R23 y1 y1.t2 27.6355
R24 y1.n2 y1.n1 2.33546
R25 y1 y1.n3 0.58424
R26 y1.n3 y1.n2 0.58424
R27 y1.n1 y1.n0 0.15419
R28 x2.n0 x2.t3 3735.06
R29 x2.n0 x2.t4 3734.47
R30 x2.n1 x2.t5 3734.47
R31 x2.n2 x2.t1 2710.06
R32 x2 x2.t0 145.054
R33 x2.n3 x2.t2 30.6969
R34 x2 x2.n3 1.16798
R35 x2.n2 x2.n1 0.58424
R36 x2.n1 x2.n0 0.58424
R37 x2.n3 x2.n2 0.15419
R38 inn inn.t0 455.483
R39 x1.n0 x1.t3 3734.58
R40 x1.n0 x1.t4 3733.99
R41 x1.n1 x1.t5 3733.99
R42 x1.n2 x1.t1 2709.58
R43 x1 x1.t0 144.575
R44 x1.n3 x1.t2 30.2161
R45 x1.n2 x1.n1 2.9192
R46 x1 x1.n3 1.16798
R47 x1.n1 x1.n0 0.58424
R48 x1.n3 x1.n2 0.15419
R49 inp inp.t0 455.962
R50 t1.n0 t1.t1 143.715
R51 t1.n0 t1.t2 143.131
R52 t1 t1.t0 69.9034
R53 t1 t1.n0 0.53348
R54 s1t s1t.t0 826.694
R55 vdd.n27 vdd.n24 8858.82
R56 vdd.n30 vdd.n26 8858.82
R57 vdd.n39 vdd.n36 8858.82
R58 vdd.n42 vdd.n38 8858.82
R59 vdd.n73 vdd.n70 3134.12
R60 vdd.n76 vdd.n72 3134.12
R61 vdd.n4 vdd.n1 2481.18
R62 vdd.n7 vdd.n3 2481.18
R63 vdd.n15 vdd.n12 2481.18
R64 vdd.n18 vdd.n14 2481.18
R65 vdd.n50 vdd.n47 1775.29
R66 vdd.n53 vdd.n49 1775.29
R67 vdd.n61 vdd.n58 1775.29
R68 vdd.n64 vdd.n60 1775.29
R69 vdd.n32 vdd.n31 944.942
R70 vdd.n31 vdd.n25 944.942
R71 vdd.n32 vdd.n23 944.942
R72 vdd.n25 vdd.n23 944.942
R73 vdd.n44 vdd.n43 944.942
R74 vdd.n43 vdd.n37 944.942
R75 vdd.n44 vdd.n35 944.942
R76 vdd.n37 vdd.n35 944.942
R77 vdd.n78 vdd.n77 334.307
R78 vdd.n77 vdd.n71 334.307
R79 vdd.n78 vdd.n69 334.307
R80 vdd.n71 vdd.n69 334.307
R81 vdd.n9 vdd.n8 264.659
R82 vdd.n8 vdd.n2 264.659
R83 vdd.n9 vdd.n0 264.659
R84 vdd.n2 vdd.n0 264.659
R85 vdd.n20 vdd.n19 264.659
R86 vdd.n19 vdd.n13 264.659
R87 vdd.n20 vdd.n11 264.659
R88 vdd.n13 vdd.n11 264.659
R89 vdd.n53 vdd.n52 190
R90 vdd.n51 vdd.n50 190
R91 vdd.n64 vdd.n63 190
R92 vdd.n62 vdd.n61 190
R93 vdd.n55 vdd.n54 189.365
R94 vdd.n54 vdd.n48 189.365
R95 vdd.n55 vdd.n46 189.365
R96 vdd.n48 vdd.n46 189.365
R97 vdd.n66 vdd.n65 189.365
R98 vdd.n65 vdd.n59 189.365
R99 vdd.n66 vdd.n57 189.365
R100 vdd.n59 vdd.n57 189.365
R101 vdd.n7 vdd.n6 126.421
R102 vdd.n5 vdd.n4 126.421
R103 vdd.n18 vdd.n17 126.421
R104 vdd.n16 vdd.n15 126.421
R105 vdd.n76 vdd.n75 104.975
R106 vdd.n74 vdd.n73 104.975
R107 vdd.n9 vdd.n1 92.5005
R108 vdd.n3 vdd.n2 92.5005
R109 vdd.n20 vdd.n12 92.5005
R110 vdd.n14 vdd.n13 92.5005
R111 vdd.n10 vdd.t10 87.4923
R112 vdd.n6 vdd.n1 84.6328
R113 vdd.n5 vdd.n3 84.6328
R114 vdd.n17 vdd.n12 84.6328
R115 vdd.n16 vdd.n14 84.6328
R116 vdd.n68 vdd.t2 70.3842
R117 vdd.n32 vdd.n24 61.6672
R118 vdd.n26 vdd.n25 61.6672
R119 vdd.n44 vdd.n36 61.6672
R120 vdd.n38 vdd.n37 61.6672
R121 vdd.n55 vdd.n47 61.6672
R122 vdd.n49 vdd.n48 61.6672
R123 vdd.n66 vdd.n58 61.6672
R124 vdd.n60 vdd.n59 61.6672
R125 vdd.n78 vdd.n70 61.6672
R126 vdd.n72 vdd.n71 61.6672
R127 vdd.n29 vdd.n24 60.9963
R128 vdd.n41 vdd.n36 60.9963
R129 vdd.n28 vdd.n26 60.9963
R130 vdd.n40 vdd.n38 60.9963
R131 vdd.n75 vdd.n70 58.4521
R132 vdd.n74 vdd.n72 58.4521
R133 vdd.n52 vdd.n47 53.2193
R134 vdd.n51 vdd.n49 53.2193
R135 vdd.n63 vdd.n58 53.2193
R136 vdd.n62 vdd.n60 53.2193
R137 vdd.n22 vdd.t7 37.2447
R138 vdd.n34 vdd.t5 37.2447
R139 vdd.n33 vdd.n32 35.5155
R140 vdd.n45 vdd.n44 35.5155
R141 vdd.n56 vdd.n55 35.5155
R142 vdd.n67 vdd.n66 35.5155
R143 vdd vdd.n78 35.5155
R144 vdd.n10 vdd.n9 35.5009
R145 vdd.n21 vdd.n20 35.5009
R146 vdd.n30 vdd.n29 35.4565
R147 vdd.n42 vdd.n41 35.4565
R148 vdd.n28 vdd.n27 35.4565
R149 vdd.n40 vdd.n39 35.4565
R150 vdd.n54 vdd.n53 23.1255
R151 vdd.n50 vdd.n46 23.1255
R152 vdd.n65 vdd.n64 23.1255
R153 vdd.n61 vdd.n57 23.1255
R154 vdd.n8 vdd.n7 13.2148
R155 vdd.n4 vdd.n0 13.2148
R156 vdd.n19 vdd.n18 13.2148
R157 vdd.n15 vdd.n11 13.2148
R158 vdd.n77 vdd.n76 9.73734
R159 vdd.n73 vdd.n69 9.73734
R160 vdd.t0 vdd.n51 6.60083
R161 vdd.n52 vdd.t0 6.60083
R162 vdd.t3 vdd.n62 6.60083
R163 vdd.n63 vdd.t3 6.60083
R164 vdd.n56 vdd.n45 5.25416
R165 vdd.t9 vdd.n5 4.71403
R166 vdd.n6 vdd.t9 4.71403
R167 vdd.t8 vdd.n16 4.71403
R168 vdd.n17 vdd.t8 4.71403
R169 vdd.n31 vdd.n30 2.76169
R170 vdd.n27 vdd.n23 2.76169
R171 vdd.n43 vdd.n42 2.76169
R172 vdd.n39 vdd.n35 2.76169
R173 vdd.t1 vdd.n74 2.06647
R174 vdd.n75 vdd.t1 2.06647
R175 vdd.n22 vdd.n21 1.58487
R176 vdd.n67 vdd.n56 0.58424
R177 vdd.n21 vdd.n10 0.57766
R178 vdd.n68 vdd.n67 0.43055
R179 vdd.n34 vdd.n33 0.43055
R180 vdd.n29 vdd.t6 0.247807
R181 vdd.n41 vdd.t4 0.247807
R182 vdd.t6 vdd.n28 0.247807
R183 vdd.t4 vdd.n40 0.247807
R184 vdd vdd.n68 0.15419
R185 vdd.n45 vdd.n34 0.15419
R186 vdd.n33 vdd.n22 0.15419
R187 vss.n65 vss.n33 22707.1
R188 vss.n41 vss.n33 22707.1
R189 vss.n65 vss.n32 22707.1
R190 vss.n41 vss.n32 22707.1
R191 vss.n73 vss.n31 22707.1
R192 vss.n73 vss.n30 22707.1
R193 vss.n72 vss.n31 22707.1
R194 vss.n72 vss.n30 22707.1
R195 vss.n80 vss.n24 22707.1
R196 vss.n68 vss.n24 22707.1
R197 vss.n80 vss.n23 22707.1
R198 vss.n68 vss.n23 22707.1
R199 vss.n88 vss.n22 22707.1
R200 vss.n88 vss.n21 22707.1
R201 vss.n87 vss.n22 22707.1
R202 vss.n87 vss.n21 22707.1
R203 vss.n95 vss.n15 22707.1
R204 vss.n83 vss.n15 22707.1
R205 vss.n95 vss.n14 22707.1
R206 vss.n83 vss.n14 22707.1
R207 vss.n103 vss.n13 22707.1
R208 vss.n103 vss.n12 22707.1
R209 vss.n102 vss.n13 22707.1
R210 vss.n102 vss.n12 22707.1
R211 vss.n110 vss.n6 16519
R212 vss.n98 vss.n6 16519
R213 vss.n110 vss.n5 16519
R214 vss.n98 vss.n5 16519
R215 vss.n116 vss.n3 16519
R216 vss.n114 vss.n4 16519
R217 vss.n114 vss.n3 16519
R218 vss.n53 vss.n42 6410.81
R219 vss.n47 vss.n44 4044.29
R220 vss.n51 vss.n44 4044.29
R221 vss.n51 vss.n43 4044.29
R222 vss.n58 vss.n39 3714.03
R223 vss.n56 vss.n40 3714.03
R224 vss.n56 vss.n39 3714.03
R225 vss.n54 vss.n53 1628.43
R226 vss.n53 vss.n52 1628.43
R227 vss.n64 vss.n63 1475.39
R228 vss.n63 vss.n35 1475.39
R229 vss.n64 vss.n34 1475.39
R230 vss.n35 vss.n34 1475.39
R231 vss.n74 vss.n29 1475.39
R232 vss.n74 vss.n28 1475.39
R233 vss.n71 vss.n29 1475.39
R234 vss.n71 vss.n28 1475.39
R235 vss.n79 vss.n78 1475.39
R236 vss.n78 vss.n26 1475.39
R237 vss.n79 vss.n25 1475.39
R238 vss.n26 vss.n25 1475.39
R239 vss.n89 vss.n20 1475.39
R240 vss.n89 vss.n19 1475.39
R241 vss.n86 vss.n20 1475.39
R242 vss.n86 vss.n19 1475.39
R243 vss.n94 vss.n93 1475.39
R244 vss.n93 vss.n17 1475.39
R245 vss.n94 vss.n16 1475.39
R246 vss.n17 vss.n16 1475.39
R247 vss.n104 vss.n11 1475.39
R248 vss.n104 vss.n10 1475.39
R249 vss.n101 vss.n11 1475.39
R250 vss.n101 vss.n10 1475.39
R251 vss.n109 vss.n108 1073.32
R252 vss.n108 vss.n8 1073.32
R253 vss.n109 vss.n7 1073.32
R254 vss.n8 vss.n7 1073.32
R255 vss.n117 vss.n2 1073.32
R256 vss.n117 vss.n1 1073.32
R257 vss.n113 vss.n2 1073.32
R258 vss.n113 vss.n1 1073.32
R259 vss.t17 vss.n54 578.759
R260 vss.n52 vss.t16 578.759
R261 vss.n47 vss.n46 506.252
R262 vss.n57 vss.n40 502.928
R263 vss.n112 vss.n111 359.394
R264 vss.n100 vss.n99 359.394
R265 vss.n97 vss.n96 359.394
R266 vss.n85 vss.n84 359.394
R267 vss.n82 vss.n81 359.394
R268 vss.n70 vss.n69 359.394
R269 vss.n67 vss.n66 359.394
R270 vss.n44 vss.t16 292.5
R271 vss.n49 vss.n44 292.5
R272 vss.n45 vss.n43 292.5
R273 vss.t17 vss.n56 292.5
R274 vss.n56 vss.n55 292.5
R275 vss.n59 vss.n58 292.5
R276 vss.n50 vss.n49 262.776
R277 vss.n50 vss.n45 262.776
R278 vss.n49 vss.n48 262.776
R279 vss.n48 vss.n45 262.776
R280 vss.n59 vss.n38 241.319
R281 vss.n59 vss.n37 241.319
R282 vss.n55 vss.n38 241.319
R283 vss.n55 vss.n37 241.319
R284 vss.n46 vss.n43 238.629
R285 vss.n58 vss.n57 234.43
R286 vss.t0 vss.n102 195
R287 vss.n102 vss.n101 195
R288 vss.n103 vss.t0 195
R289 vss.n104 vss.n103 195
R290 vss.t8 vss.n114 195
R291 vss.n114 vss.n113 195
R292 vss.n117 vss.n116 195
R293 vss.n5 vss.t2 195
R294 vss.n7 vss.n5 195
R295 vss.n6 vss.t2 195
R296 vss.n108 vss.n6 195
R297 vss.n14 vss.t4 195
R298 vss.n16 vss.n14 195
R299 vss.n15 vss.t4 195
R300 vss.n93 vss.n15 195
R301 vss.t6 vss.n87 195
R302 vss.n87 vss.n86 195
R303 vss.n88 vss.t6 195
R304 vss.n89 vss.n88 195
R305 vss.n23 vss.t10 195
R306 vss.n25 vss.n23 195
R307 vss.n24 vss.t10 195
R308 vss.n78 vss.n24 195
R309 vss.t12 vss.n72 195
R310 vss.n72 vss.n71 195
R311 vss.n73 vss.t12 195
R312 vss.n74 vss.n73 195
R313 vss.n32 vss.t14 195
R314 vss.n34 vss.n32 195
R315 vss.n33 vss.t14 195
R316 vss.n63 vss.n33 195
R317 vss.n116 vss.n115 191.874
R318 vss.n115 vss.n4 73.0504
R319 vss.t8 vss.n112 66.6431
R320 vss.n111 vss.t2 66.6431
R321 vss.n99 vss.t2 66.6431
R322 vss.t0 vss.n100 66.6431
R323 vss.t0 vss.n97 66.6431
R324 vss.n96 vss.t4 66.6431
R325 vss.n84 vss.t4 66.6431
R326 vss.t6 vss.n85 66.6431
R327 vss.t6 vss.n82 66.6431
R328 vss.n81 vss.t10 66.6431
R329 vss.n69 vss.t10 66.6431
R330 vss.t12 vss.n70 66.6431
R331 vss.t12 vss.n67 66.6431
R332 vss.n66 vss.t14 66.6431
R333 vss.n42 vss.t14 66.6431
R334 vss.n36 vss.t18 54.1955
R335 vss.n54 vss.n39 48.7505
R336 vss.n39 vss.n37 48.7505
R337 vss.n40 vss.n38 48.7505
R338 vss.n52 vss.n51 41.7862
R339 vss.n51 vss.n50 41.7862
R340 vss.n48 vss.n47 41.7862
R341 vss.n57 vss.t17 39.6093
R342 vss.n46 vss.t16 36.6152
R343 vss.n49 vss.n36 36.4052
R344 vss.n63 vss.n62 35.9963
R345 vss.n75 vss.n74 35.9963
R346 vss.n78 vss.n77 35.9963
R347 vss.n90 vss.n89 35.9963
R348 vss.n93 vss.n92 35.9963
R349 vss.n108 vss.n107 35.9963
R350 vss vss.n117 35.9963
R351 vss.n105 vss.n104 35.9963
R352 vss.n60 vss.n59 35.9817
R353 vss.n106 vss.t3 29.7353
R354 vss.n0 vss.t9 29.7353
R355 vss.n61 vss.t15 26.1932
R356 vss.n27 vss.t13 26.1932
R357 vss.n76 vss.t11 26.1932
R358 vss.n18 vss.t7 26.1932
R359 vss.n91 vss.t5 26.1932
R360 vss.n9 vss.t1 26.1932
R361 vss.n112 vss.n3 7.5979
R362 vss.n3 vss.n1 7.5979
R363 vss.n4 vss.n2 7.5979
R364 vss.n99 vss.n98 7.5979
R365 vss.n98 vss.n8 7.5979
R366 vss.n111 vss.n110 7.5979
R367 vss.n110 vss.n109 7.5979
R368 vss.n97 vss.n12 5.36747
R369 vss.n12 vss.n10 5.36747
R370 vss.n100 vss.n13 5.36747
R371 vss.n13 vss.n11 5.36747
R372 vss.n84 vss.n83 5.36747
R373 vss.n83 vss.n17 5.36747
R374 vss.n96 vss.n95 5.36747
R375 vss.n95 vss.n94 5.36747
R376 vss.n82 vss.n21 5.36747
R377 vss.n21 vss.n19 5.36747
R378 vss.n85 vss.n22 5.36747
R379 vss.n22 vss.n20 5.36747
R380 vss.n69 vss.n68 5.36747
R381 vss.n68 vss.n26 5.36747
R382 vss.n81 vss.n80 5.36747
R383 vss.n80 vss.n79 5.36747
R384 vss.n67 vss.n30 5.36747
R385 vss.n30 vss.n28 5.36747
R386 vss.n70 vss.n31 5.36747
R387 vss.n31 vss.n29 5.36747
R388 vss.n42 vss.n41 5.36747
R389 vss.n41 vss.n35 5.36747
R390 vss.n66 vss.n65 5.36747
R391 vss.n65 vss.n64 5.36747
R392 vss.n61 vss.n60 1.59803
R393 vss.n115 vss.t8 0.863317
R394 vss.n107 vss.n0 0.43055
R395 vss.n106 vss.n105 0.43055
R396 vss.n92 vss.n9 0.43055
R397 vss.n91 vss.n90 0.43055
R398 vss.n77 vss.n18 0.43055
R399 vss.n76 vss.n75 0.43055
R400 vss.n62 vss.n27 0.43055
R401 vss vss.n0 0.15419
R402 vss.n107 vss.n106 0.15419
R403 vss.n105 vss.n9 0.15419
R404 vss.n92 vss.n91 0.15419
R405 vss.n90 vss.n18 0.15419
R406 vss.n77 vss.n76 0.15419
R407 vss.n75 vss.n27 0.15419
R408 vss.n62 vss.n61 0.15419
R409 vss.n60 vss.n36 0.15419
C0 vdd out 0.46306f
C1 out o1 0.38984f
C2 inp vdd 0.64099f
C3 vdd s2cn 0.45469f
C4 vdd s2a 0.05054f
C5 s2cn o1 0.0721f
C6 s2cp out 0.72161f
C7 inp s1t 0
C8 s2a o1 0.9188f
C9 inp x2 0
C10 s2cp s2cn 0.00266f
C11 s2cp s2a 0
C12 y1 x1 0.5701f
C13 t1 inn 0.06617f
C14 x1 inn 0
C15 s2c vdd 4.0392f
C16 s2c o1 0.88744f
C17 s2cn out 0.79654f
C18 s2a out 2.41125f
C19 x1 t1 2.33534f
C20 y1 vdd 7.1647f
C21 s2cp s2c 0.21496f
C22 s2a s2cn 0.11731f
C23 y1 o1 1.08681f
C24 x2 y1 4.18165f
C25 vdd inn 0.23306f
C26 x2 inn 0.68509f
C27 t1 vdd 5.4659f
C28 s2c out 2.48448f
C29 s1t t1 0.77657f
C30 x1 vdd 1.04886f
C31 x2 t1 2.27323f
C32 x1 o1 3.10526f
C33 s1t x1 0
C34 s2c s2cn 0
C35 x2 x1 1.79546f
C36 s2c s2a 0
C37 y1 s2a 0
C38 vdd o1 5.56901f
C39 inp inn 0.00285f
C40 s1t vdd 0.78861f
C41 x2 vdd 0.62846f
C42 x2 o1 0
C43 s2cp vdd 0.71069f
C44 inp t1 0.07044f
C45 s2cp o1 0.08261f
C46 inp x1 0.70001f
C47 s2c vss 8.05848f
C48 s2cp vss 3.2306f
C49 out vss 7.2977f
C50 s2cn vss 3.17345f
C51 s2a vss 8.09721f
C52 o1 vss 30.86775f
C53 y1 vss 31.22485f
C54 x2 vss 18.649f
C55 inn vss 2.75472f
C56 x1 vss 20.42107f
C57 inp vss 2.76316f
C58 t1 vss 6.08289f
C59 s1t vss 2.81847f
C60 vdd vss 51.22049f
C61 vss.t9 vss 0.18706f
C62 vss.t1 vss 0.28501f
C63 vss.t7 vss 0.28507f
C64 vss.t13 vss 0.26067f
C65 vss.t18 vss 0.02932f
C66 vss.t15 vss 0.26072f
C67 vss.t11 vss 0.26067f
C68 vss.t5 vss 0.28501f
C69 vss.t3 vss 0.20458f
C70 vdd.t10 vss 0.26949f
C71 vdd.n0 vss 0.03587f
C72 vdd.n1 vss 0.0368f
C73 vdd.n2 vss 0.0368f
C74 vdd.n3 vss 0.0368f
C75 vdd.n4 vss 0.2552f
C76 vdd.t9 vss 0.33887f
C77 vdd.n7 vss 0.2552f
C78 vdd.n8 vss 0.03587f
C79 vdd.n9 vss 0.43055f
C80 vdd.n10 vss 1.28557f
C81 vdd.n11 vss 0.03587f
C82 vdd.n12 vss 0.0368f
C83 vdd.n13 vss 0.0368f
C84 vdd.n14 vss 0.0368f
C85 vdd.n15 vss 0.2552f
C86 vdd.t8 vss 0.33887f
C87 vdd.n18 vss 0.2552f
C88 vdd.n19 vss 0.03587f
C89 vdd.n20 vss 0.43055f
C90 vdd.n21 vss 0.78826f
C91 vdd.t7 vss 1.12443f
C92 vdd.n22 vss 0.83361f
C93 vdd.n23 vss 0.12678f
C94 vdd.n24 vss 0.12826f
C95 vdd.n25 vss 0.12826f
C96 vdd.n26 vss 0.12826f
C97 vdd.n27 vss 1.03211f
C98 vdd.t6 vss 1.35397f
C99 vdd.n30 vss 1.03211f
C100 vdd.n31 vss 0.12678f
C101 vdd.n32 vss 0.52288f
C102 vdd.n33 vss 0.53936f
C103 vdd.t5 vss 1.12432f
C104 vdd.n34 vss 0.65135f
C105 vdd.n35 vss 0.12678f
C106 vdd.n36 vss 0.12826f
C107 vdd.n37 vss 0.12826f
C108 vdd.n38 vss 0.12826f
C109 vdd.n39 vss 1.03211f
C110 vdd.t4 vss 1.35397f
C111 vdd.n42 vss 1.03211f
C112 vdd.n43 vss 0.12678f
C113 vdd.n44 vss 0.52288f
C114 vdd.n45 vss 1.30099f
C115 vdd.n46 vss 0.02596f
C116 vdd.n47 vss 0.02653f
C117 vdd.n48 vss 0.02653f
C118 vdd.n49 vss 0.02653f
C119 vdd.n50 vss 0.17336f
C120 vdd.t0 vss 0.23657f
C121 vdd.n53 vss 0.17336f
C122 vdd.n54 vss 0.02596f
C123 vdd.n55 vss 0.42115f
C124 vdd.n56 vss 1.36889f
C125 vdd.n57 vss 0.02596f
C126 vdd.n58 vss 0.02653f
C127 vdd.n59 vss 0.02653f
C128 vdd.n60 vss 0.02653f
C129 vdd.n61 vss 0.17336f
C130 vdd.t3 vss 0.23657f
C131 vdd.n64 vss 0.17336f
C132 vdd.n65 vss 0.02596f
C133 vdd.n66 vss 0.42115f
C134 vdd.n67 vss 0.60727f
C135 vdd.t2 vss 0.41093f
C136 vdd.n68 vss 0.76182f
C137 vdd.n69 vss 0.04514f
C138 vdd.n70 vss 0.0462f
C139 vdd.n71 vss 0.0462f
C140 vdd.n72 vss 0.0462f
C141 vdd.n73 vss 0.33816f
C142 vdd.t1 vss 0.45046f
C143 vdd.n76 vss 0.33816f
C144 vdd.n77 vss 0.04514f
C145 vdd.n78 vss 0.44082f
C146 t1.t1 vss 0.50885f
C147 t1.t2 vss 0.51294f
C148 t1.n0 vss 6.1987f
C149 t1.t0 vss 1.22776f
C150 x1.n0 vss 1.40405f
C151 x1.n1 vss 1.21664f
C152 x1.n2 vss 1.2868f
C153 x1.t2 vss 1.7477f
C154 x1.n3 vss 0.79466f
C155 x1.t0 vss 0.22324f
C156 x2.n0 vss 1.57697f
C157 x2.n1 vss 0.84653f
C158 x2.n2 vss 0.92316f
C159 x2.t2 vss 1.92224f
C160 x2.n3 vss 0.87828f
C161 x2.t0 vss 0.22677f
C162 y1.n0 vss 1.72502f
C163 y1.t4 vss 1.35536f
C164 y1.n1 vss 1.17219f
C165 y1.t0 vss 2.27364f
C166 y1.n2 vss 1.02619f
C167 y1.t1 vss 2.27358f
C168 y1.n3 vss 0.69535f
C169 y1.t2 vss 2.27358f
C170 o1.n0 vss 2.36f
C171 o1.t0 vss 1.25366f
C172 o1.n1 vss 0.98296f
C173 o1.t1 vss 2.15823f
C174 o1.n2 vss 0.7282f
C175 o1.t2 vss 2.15818f
C176 o1.n3 vss 0.61565f
C177 o1.t3 vss 2.15818f
C178 s2a.t1 vss 0.66267f
C179 s2a.t0 vss 0.58042f
C180 out.t1 vss 0.89262f
C181 out.t0 vss 1.26699f
C182 s2c.t1 vss 0.91057f
C183 s2c.t0 vss 0.9161f
.ends
