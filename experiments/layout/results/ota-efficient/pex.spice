* NGSPICE file created from layout.ext - technology: sky130A

.subckt layout inn inp out s1t t1 vdd vss x1
X0 x1.t18 x1.t17 vss.t3 vss.t2 sky130_fd_pr__nfet_01v8 ad=7.6763 pd=53.52 as=7.6763 ps=53.52 w=26.47 l=1.7
X1 x1.t8 inp.t8 t1.t28 vdd.t25 sky130_fd_pr__pfet_01v8 ad=14.471 pd=100.38 as=14.471 ps=100.38 w=49.9 l=1.7
X2 x1.t16 inp.t6 t1.t30 vdd.t27 sky130_fd_pr__pfet_01v8 ad=14.471 pd=100.38 as=14.471 ps=100.38 w=49.9 l=1.7
X3 x1.t14 inp.t13 t1.t23 vdd.t20 sky130_fd_pr__pfet_01v8 ad=14.471 pd=100.38 as=14.471 ps=100.38 w=49.9 l=1.7
X4 out.t12 inn.t6 t1.t13 vdd.t10 sky130_fd_pr__pfet_01v8 ad=14.471 pd=100.38 as=14.471 ps=100.38 w=49.9 l=1.7
X5 t1.t2 s1t.t1 vdd.t37 vdd.t36 sky130_fd_pr__pfet_01v8 ad=10.8402 pd=75.34 as=10.8402 ps=75.34 w=37.38 l=1.7
X6 out.t16 x1.t19 vss.t1 vss.t0 sky130_fd_pr__nfet_01v8 ad=7.6763 pd=53.52 as=7.6763 ps=53.52 w=26.47 l=1.7
X7 x1.t6 inp.t2 t1.t34 vdd.t31 sky130_fd_pr__pfet_01v8 ad=14.471 pd=100.38 as=14.471 ps=100.38 w=49.9 l=1.7
X8 x1.t7 inp.t14 t1.t22 vdd.t19 sky130_fd_pr__pfet_01v8 ad=14.471 pd=100.38 as=14.471 ps=100.38 w=49.9 l=1.7
X9 out.t7 inn.t7 t1.t12 vdd.t9 sky130_fd_pr__pfet_01v8 ad=14.471 pd=100.38 as=14.471 ps=100.38 w=49.9 l=1.7
X10 out.t8 inn.t0 t1.t19 vdd.t16 sky130_fd_pr__pfet_01v8 ad=14.471 pd=100.38 as=14.471 ps=100.38 w=49.9 l=1.7
X11 x1.t12 inp.t10 t1.t26 vdd.t23 sky130_fd_pr__pfet_01v8 ad=14.471 pd=100.38 as=14.471 ps=100.38 w=49.9 l=1.7
X12 out.t0 inn.t13 t1.t6 vdd.t3 sky130_fd_pr__pfet_01v8 ad=14.471 pd=100.38 as=14.471 ps=100.38 w=49.9 l=1.7
X13 x1.t9 inp.t3 t1.t33 vdd.t30 sky130_fd_pr__pfet_01v8 ad=14.471 pd=100.38 as=14.471 ps=100.38 w=49.9 l=1.7
X14 out.t17 inn.t8 t1.t11 vdd.t8 sky130_fd_pr__pfet_01v8 ad=14.471 pd=100.38 as=14.471 ps=100.38 w=49.9 l=1.7
X15 out.t6 inn.t1 t1.t18 vdd.t15 sky130_fd_pr__pfet_01v8 ad=14.471 pd=100.38 as=14.471 ps=100.38 w=49.9 l=1.7
X16 x1.t1 inp.t9 t1.t27 vdd.t24 sky130_fd_pr__pfet_01v8 ad=14.471 pd=100.38 as=14.471 ps=100.38 w=49.9 l=1.7
X17 out.t14 inn.t14 t1.t5 vdd.t2 sky130_fd_pr__pfet_01v8 ad=14.471 pd=100.38 as=14.471 ps=100.38 w=49.9 l=1.7
X18 x1.t2 inp.t4 t1.t32 vdd.t29 sky130_fd_pr__pfet_01v8 ad=14.471 pd=100.38 as=14.471 ps=100.38 w=49.9 l=1.7
X19 x1.t15 inp.t16 t1.t20 vdd.t17 sky130_fd_pr__pfet_01v8 ad=14.471 pd=100.38 as=14.471 ps=100.38 w=49.9 l=1.7
X20 out.t11 inn.t2 t1.t17 vdd.t14 sky130_fd_pr__pfet_01v8 ad=14.471 pd=100.38 as=14.471 ps=100.38 w=49.9 l=1.7
X21 x1.t11 inp.t15 t1.t21 vdd.t18 sky130_fd_pr__pfet_01v8 ad=14.471 pd=100.38 as=14.471 ps=100.38 w=49.9 l=1.7
X22 x1.t10 inp.t5 t1.t31 vdd.t28 sky130_fd_pr__pfet_01v8 ad=14.471 pd=100.38 as=14.471 ps=100.38 w=49.9 l=1.7
X23 out.t4 inn.t15 t1.t4 vdd.t1 sky130_fd_pr__pfet_01v8 ad=14.471 pd=100.38 as=14.471 ps=100.38 w=49.9 l=1.7
X24 out.t10 inn.t5 t1.t14 vdd.t11 sky130_fd_pr__pfet_01v8 ad=14.471 pd=100.38 as=14.471 ps=100.38 w=49.9 l=1.7
X25 out.t5 inn.t3 t1.t16 vdd.t13 sky130_fd_pr__pfet_01v8 ad=14.471 pd=100.38 as=14.471 ps=100.38 w=49.9 l=1.7
X26 x1.t4 inp.t11 t1.t25 vdd.t22 sky130_fd_pr__pfet_01v8 ad=14.471 pd=100.38 as=14.471 ps=100.38 w=49.9 l=1.7
X27 x1.t3 inp.t1 t1.t35 vdd.t32 sky130_fd_pr__pfet_01v8 ad=14.471 pd=100.38 as=14.471 ps=100.38 w=49.9 l=1.7
X28 out.t13 inn.t4 t1.t15 vdd.t12 sky130_fd_pr__pfet_01v8 ad=14.471 pd=100.38 as=14.471 ps=100.38 w=49.9 l=1.7
X29 out.t1 inn.t11 t1.t8 vdd.t5 sky130_fd_pr__pfet_01v8 ad=14.471 pd=100.38 as=14.471 ps=100.38 w=49.9 l=1.7
X30 out.t15 inn.t9 t1.t10 vdd.t7 sky130_fd_pr__pfet_01v8 ad=14.471 pd=100.38 as=14.471 ps=100.38 w=49.9 l=1.7
X31 out.t2 inn.t16 t1.t3 vdd.t0 sky130_fd_pr__pfet_01v8 ad=14.471 pd=100.38 as=14.471 ps=100.38 w=49.9 l=1.7
X32 x1.t0 inp.t7 t1.t29 vdd.t26 sky130_fd_pr__pfet_01v8 ad=14.471 pd=100.38 as=14.471 ps=100.38 w=49.9 l=1.7
X33 x1.t5 inp.t12 t1.t24 vdd.t21 sky130_fd_pr__pfet_01v8 ad=14.471 pd=100.38 as=14.471 ps=100.38 w=49.9 l=1.7
X34 x1.t13 inp.t0 t1.t36 vdd.t33 sky130_fd_pr__pfet_01v8 ad=14.471 pd=100.38 as=14.471 ps=100.38 w=49.9 l=1.7
X35 t1.t1 s1t.t2 vdd.t35 vdd.t34 sky130_fd_pr__pfet_01v8 ad=10.8402 pd=75.34 as=10.8402 ps=75.34 w=37.38 l=1.7
X36 t1.t0 s1t.t0 vdd.t39 vdd.t38 sky130_fd_pr__pfet_01v8 ad=10.8402 pd=75.34 as=10.8402 ps=75.34 w=37.38 l=1.7
X37 out.t3 inn.t12 t1.t7 vdd.t4 sky130_fd_pr__pfet_01v8 ad=14.471 pd=100.38 as=14.471 ps=100.38 w=49.9 l=1.7
X38 out.t9 inn.t10 t1.t9 vdd.t6 sky130_fd_pr__pfet_01v8 ad=14.471 pd=100.38 as=14.471 ps=100.38 w=49.9 l=1.7
R0 out.n0 out.t16 33.0607
R1 out.n0 out.t8 27.4785
R2 out.n1 out.t6 27.4785
R3 out.n2 out.t11 27.4785
R4 out.n3 out.t5 27.4785
R5 out.n4 out.t13 27.4785
R6 out.n5 out.t10 27.4785
R7 out.n6 out.t12 27.4785
R8 out.n7 out.t7 27.4785
R9 out.n8 out.t17 27.4785
R10 out.n9 out.t15 27.4785
R11 out.n10 out.t9 27.4785
R12 out.n11 out.t1 27.4785
R13 out.n12 out.t3 27.4785
R14 out.n13 out.t0 27.4785
R15 out.n14 out.t14 27.4785
R16 out.n15 out.t4 27.4785
R17 out out.t2 27.4785
R18 out out.n15 0.72054
R19 out.n15 out.n14 0.72054
R20 out.n14 out.n13 0.72054
R21 out.n13 out.n12 0.72054
R22 out.n12 out.n11 0.72054
R23 out.n11 out.n10 0.72054
R24 out.n10 out.n9 0.72054
R25 out.n9 out.n8 0.72054
R26 out.n8 out.n7 0.72054
R27 out.n7 out.n6 0.72054
R28 out.n6 out.n5 0.72054
R29 out.n5 out.n4 0.72054
R30 out.n4 out.n3 0.72054
R31 out.n3 out.n2 0.72054
R32 out.n2 out.n1 0.72054
R33 out.n1 out.n0 0.72054
R34 inn.n0 inn.t0 761.049
R35 inn.n0 inn.t1 760.328
R36 inn.n1 inn.t2 760.328
R37 inn.n2 inn.t3 760.328
R38 inn.n3 inn.t4 760.328
R39 inn.n4 inn.t5 760.328
R40 inn.n5 inn.t6 760.328
R41 inn.n6 inn.t7 760.328
R42 inn.n7 inn.t8 760.328
R43 inn.n8 inn.t9 760.328
R44 inn.n9 inn.t10 760.328
R45 inn.n10 inn.t11 760.328
R46 inn.n11 inn.t12 760.328
R47 inn.n12 inn.t13 760.328
R48 inn.n13 inn.t14 760.328
R49 inn.n14 inn.t15 760.328
R50 inn inn.t16 760.328
R51 inn inn.n14 0.72054
R52 inn.n14 inn.n13 0.72054
R53 inn.n13 inn.n12 0.72054
R54 inn.n12 inn.n11 0.72054
R55 inn.n11 inn.n10 0.72054
R56 inn.n10 inn.n9 0.72054
R57 inn.n9 inn.n8 0.72054
R58 inn.n8 inn.n7 0.72054
R59 inn.n7 inn.n6 0.72054
R60 inn.n6 inn.n5 0.72054
R61 inn.n5 inn.n4 0.72054
R62 inn.n4 inn.n3 0.72054
R63 inn.n3 inn.n2 0.72054
R64 inn.n2 inn.n1 0.72054
R65 inn.n1 inn.n0 0.72054
R66 x1.n0 x1.t19 442.269
R67 x1.n0 x1.t17 441.55
R68 x1.n1 x1.t18 34.0245
R69 x1.n2 x1.t13 29.8824
R70 x1.n3 x1.t3 29.8824
R71 x1.n4 x1.t6 29.8824
R72 x1.n5 x1.t9 29.8824
R73 x1.n6 x1.t2 29.8824
R74 x1.n7 x1.t10 29.8824
R75 x1.n8 x1.t16 29.8824
R76 x1.n9 x1.t0 29.8824
R77 x1.n10 x1.t8 29.8824
R78 x1.n11 x1.t1 29.8824
R79 x1.n12 x1.t12 29.8824
R80 x1.n13 x1.t4 29.8824
R81 x1.n14 x1.t5 29.8824
R82 x1.n15 x1.t14 29.8824
R83 x1.n16 x1.t7 29.8824
R84 x1.n17 x1.t11 29.8824
R85 x1 x1.t15 29.8824
R86 x1.n2 x1.n1 12.9612
R87 x1 x1.n17 0.72054
R88 x1.n17 x1.n16 0.72054
R89 x1.n16 x1.n15 0.72054
R90 x1.n15 x1.n14 0.72054
R91 x1.n14 x1.n13 0.72054
R92 x1.n13 x1.n12 0.72054
R93 x1.n12 x1.n11 0.72054
R94 x1.n11 x1.n10 0.72054
R95 x1.n10 x1.n9 0.72054
R96 x1.n9 x1.n8 0.72054
R97 x1.n8 x1.n7 0.72054
R98 x1.n7 x1.n6 0.72054
R99 x1.n6 x1.n5 0.72054
R100 x1.n5 x1.n4 0.72054
R101 x1.n4 x1.n3 0.72054
R102 x1.n3 x1.n2 0.72054
R103 x1.n1 x1.n0 0.15419
R104 inp.n0 inp.t0 761.529
R105 inp.n0 inp.t1 760.809
R106 inp.n1 inp.t2 760.809
R107 inp.n2 inp.t3 760.809
R108 inp.n3 inp.t4 760.809
R109 inp.n4 inp.t5 760.809
R110 inp.n5 inp.t6 760.809
R111 inp.n6 inp.t7 760.809
R112 inp.n7 inp.t8 760.809
R113 inp.n8 inp.t9 760.809
R114 inp.n9 inp.t10 760.809
R115 inp.n10 inp.t11 760.809
R116 inp.n11 inp.t12 760.809
R117 inp.n12 inp.t13 760.809
R118 inp.n13 inp.t14 760.809
R119 inp.n14 inp.t15 760.809
R120 inp inp.t16 760.809
R121 inp inp.n14 0.72054
R122 inp.n14 inp.n13 0.72054
R123 inp.n13 inp.n12 0.72054
R124 inp.n12 inp.n11 0.72054
R125 inp.n11 inp.n10 0.72054
R126 inp.n10 inp.n9 0.72054
R127 inp.n9 inp.n8 0.72054
R128 inp.n8 inp.n7 0.72054
R129 inp.n7 inp.n6 0.72054
R130 inp.n6 inp.n5 0.72054
R131 inp.n5 inp.n4 0.72054
R132 inp.n4 inp.n3 0.72054
R133 inp.n3 inp.n2 0.72054
R134 inp.n2 inp.n1 0.72054
R135 inp.n1 inp.n0 0.72054
R136 t1.n33 t1.t0 32.9748
R137 t1.n34 t1.t2 32.9748
R138 t1 t1.t1 32.9748
R139 t1.n0 t1.t19 29.1601
R140 t1.n0 t1.t18 28.4401
R141 t1.n1 t1.t17 28.4401
R142 t1.n2 t1.t16 28.4401
R143 t1.n3 t1.t15 28.4401
R144 t1.n4 t1.t14 28.4401
R145 t1.n5 t1.t13 28.4401
R146 t1.n6 t1.t12 28.4401
R147 t1.n7 t1.t11 28.4401
R148 t1.n8 t1.t10 28.4401
R149 t1.n9 t1.t9 28.4401
R150 t1.n10 t1.t8 28.4401
R151 t1.n11 t1.t7 28.4401
R152 t1.n12 t1.t6 28.4401
R153 t1.n13 t1.t5 28.4401
R154 t1.n14 t1.t4 28.4401
R155 t1.n15 t1.t3 28.4401
R156 t1.n16 t1.t36 28.4401
R157 t1.n17 t1.t35 28.4401
R158 t1.n18 t1.t34 28.4401
R159 t1.n19 t1.t33 28.4401
R160 t1.n20 t1.t32 28.4401
R161 t1.n21 t1.t31 28.4401
R162 t1.n22 t1.t30 28.4401
R163 t1.n23 t1.t29 28.4401
R164 t1.n24 t1.t28 28.4401
R165 t1.n25 t1.t27 28.4401
R166 t1.n26 t1.t26 28.4401
R167 t1.n27 t1.t25 28.4401
R168 t1.n28 t1.t24 28.4401
R169 t1.n29 t1.t23 28.4401
R170 t1.n30 t1.t22 28.4401
R171 t1.n31 t1.t21 28.4401
R172 t1.n32 t1.t20 28.4401
R173 t1 t1.n34 0.72054
R174 t1.n34 t1.n33 0.72054
R175 t1.n32 t1.n31 0.72054
R176 t1.n31 t1.n30 0.72054
R177 t1.n30 t1.n29 0.72054
R178 t1.n29 t1.n28 0.72054
R179 t1.n28 t1.n27 0.72054
R180 t1.n27 t1.n26 0.72054
R181 t1.n26 t1.n25 0.72054
R182 t1.n25 t1.n24 0.72054
R183 t1.n24 t1.n23 0.72054
R184 t1.n23 t1.n22 0.72054
R185 t1.n22 t1.n21 0.72054
R186 t1.n21 t1.n20 0.72054
R187 t1.n20 t1.n19 0.72054
R188 t1.n19 t1.n18 0.72054
R189 t1.n18 t1.n17 0.72054
R190 t1.n17 t1.n16 0.72054
R191 t1.n16 t1.n15 0.72054
R192 t1.n15 t1.n14 0.72054
R193 t1.n14 t1.n13 0.72054
R194 t1.n13 t1.n12 0.72054
R195 t1.n12 t1.n11 0.72054
R196 t1.n11 t1.n10 0.72054
R197 t1.n10 t1.n9 0.72054
R198 t1.n9 t1.n8 0.72054
R199 t1.n8 t1.n7 0.72054
R200 t1.n7 t1.n6 0.72054
R201 t1.n6 t1.n5 0.72054
R202 t1.n5 t1.n4 0.72054
R203 t1.n4 t1.n3 0.72054
R204 t1.n3 t1.n2 0.72054
R205 t1.n2 t1.n1 0.72054
R206 t1.n1 t1.n0 0.72054
R207 t1.n33 t1.n32 0.53348
R208 s1t.n0 s1t.t0 591.021
R209 s1t s1t.t2 590.302
R210 s1t.n0 s1t.t1 590.302
R211 s1t s1t.n0 0.72054
R212 vdd.n39 vdd.n35 14700
R213 vdd.n40 vdd.n37 14700
R214 vdd.n50 vdd.n46 14700
R215 vdd.n51 vdd.n48 14700
R216 vdd.n61 vdd.n57 14700
R217 vdd.n62 vdd.n59 14700
R218 vdd.n0 vdd.t16 89.7425
R219 vdd.n0 vdd.t15 89.0225
R220 vdd.n1 vdd.t14 89.0225
R221 vdd.n2 vdd.t13 89.0225
R222 vdd.n3 vdd.t12 89.0225
R223 vdd.n4 vdd.t11 89.0225
R224 vdd.n5 vdd.t10 89.0225
R225 vdd.n6 vdd.t9 89.0225
R226 vdd.n7 vdd.t8 89.0225
R227 vdd.n8 vdd.t7 89.0225
R228 vdd.n9 vdd.t6 89.0225
R229 vdd.n10 vdd.t5 89.0225
R230 vdd.n11 vdd.t4 89.0225
R231 vdd.n12 vdd.t3 89.0225
R232 vdd.n13 vdd.t2 89.0225
R233 vdd.n14 vdd.t1 89.0225
R234 vdd.n15 vdd.t0 89.0225
R235 vdd.n16 vdd.t33 89.0225
R236 vdd.n17 vdd.t32 89.0225
R237 vdd.n18 vdd.t31 89.0225
R238 vdd.n19 vdd.t30 89.0225
R239 vdd.n20 vdd.t29 89.0225
R240 vdd.n21 vdd.t28 89.0225
R241 vdd.n22 vdd.t27 89.0225
R242 vdd.n23 vdd.t26 89.0225
R243 vdd.n24 vdd.t25 89.0225
R244 vdd.n25 vdd.t24 89.0225
R245 vdd.n26 vdd.t23 89.0225
R246 vdd.n27 vdd.t22 89.0225
R247 vdd.n28 vdd.t21 89.0225
R248 vdd.n29 vdd.t20 89.0225
R249 vdd.n30 vdd.t19 89.0225
R250 vdd.n31 vdd.t18 89.0225
R251 vdd.n32 vdd.t17 89.0225
R252 vdd.n42 vdd.n41 1568
R253 vdd.n41 vdd.n36 1568
R254 vdd.n42 vdd.n34 1568
R255 vdd.n36 vdd.n34 1568
R256 vdd.n53 vdd.n52 1568
R257 vdd.n52 vdd.n47 1568
R258 vdd.n53 vdd.n45 1568
R259 vdd.n47 vdd.n45 1568
R260 vdd.n64 vdd.n63 1568
R261 vdd.n63 vdd.n58 1568
R262 vdd.n64 vdd.n56 1568
R263 vdd.n58 vdd.n56 1568
R264 vdd.n40 vdd.n38 39.3987
R265 vdd.n51 vdd.n49 39.3987
R266 vdd.n62 vdd.n60 39.3987
R267 vdd.t38 vdd.n39 39.3987
R268 vdd.t36 vdd.n50 39.3987
R269 vdd.t34 vdd.n61 39.3987
R270 vdd.n43 vdd.n42 38.7561
R271 vdd.n54 vdd.n53 38.7561
R272 vdd vdd.n64 38.7561
R273 vdd.n33 vdd.t39 33.4556
R274 vdd.n44 vdd.t37 33.4556
R275 vdd.n55 vdd.t35 33.4556
R276 vdd.n42 vdd.n35 26.4291
R277 vdd.n37 vdd.n36 26.4291
R278 vdd.n53 vdd.n46 26.4291
R279 vdd.n48 vdd.n47 26.4291
R280 vdd.n64 vdd.n57 26.4291
R281 vdd.n59 vdd.n58 26.4291
R282 vdd.n38 vdd.n35 26.3114
R283 vdd.n49 vdd.n46 26.3114
R284 vdd.n60 vdd.n57 26.3114
R285 vdd.t38 vdd.n37 26.3114
R286 vdd.t36 vdd.n48 26.3114
R287 vdd.t34 vdd.n59 26.3114
R288 vdd.n41 vdd.n40 1.66717
R289 vdd.n39 vdd.n34 1.66717
R290 vdd.n52 vdd.n51 1.66717
R291 vdd.n50 vdd.n45 1.66717
R292 vdd.n63 vdd.n62 1.66717
R293 vdd.n61 vdd.n56 1.66717
R294 vdd.n32 vdd.n31 0.72054
R295 vdd.n31 vdd.n30 0.72054
R296 vdd.n30 vdd.n29 0.72054
R297 vdd.n29 vdd.n28 0.72054
R298 vdd.n28 vdd.n27 0.72054
R299 vdd.n27 vdd.n26 0.72054
R300 vdd.n26 vdd.n25 0.72054
R301 vdd.n25 vdd.n24 0.72054
R302 vdd.n24 vdd.n23 0.72054
R303 vdd.n23 vdd.n22 0.72054
R304 vdd.n22 vdd.n21 0.72054
R305 vdd.n21 vdd.n20 0.72054
R306 vdd.n20 vdd.n19 0.72054
R307 vdd.n19 vdd.n18 0.72054
R308 vdd.n18 vdd.n17 0.72054
R309 vdd.n17 vdd.n16 0.72054
R310 vdd.n16 vdd.n15 0.72054
R311 vdd.n15 vdd.n14 0.72054
R312 vdd.n14 vdd.n13 0.72054
R313 vdd.n13 vdd.n12 0.72054
R314 vdd.n12 vdd.n11 0.72054
R315 vdd.n11 vdd.n10 0.72054
R316 vdd.n10 vdd.n9 0.72054
R317 vdd.n9 vdd.n8 0.72054
R318 vdd.n8 vdd.n7 0.72054
R319 vdd.n7 vdd.n6 0.72054
R320 vdd.n6 vdd.n5 0.72054
R321 vdd.n5 vdd.n4 0.72054
R322 vdd.n4 vdd.n3 0.72054
R323 vdd.n3 vdd.n2 0.72054
R324 vdd.n2 vdd.n1 0.72054
R325 vdd.n1 vdd.n0 0.72054
R326 vdd.n55 vdd.n54 0.56685
R327 vdd.n44 vdd.n43 0.56685
R328 vdd.n33 vdd.n32 0.56685
R329 vdd vdd.n55 0.15419
R330 vdd.n54 vdd.n44 0.15419
R331 vdd.n43 vdd.n33 0.15419
R332 vdd.n60 vdd.t34 0.143163
R333 vdd.n49 vdd.t36 0.143163
R334 vdd.n38 vdd.t38 0.143163
R335 vss.n9 vss.n6 17782.1
R336 vss.n14 vss.n6 17782.1
R337 vss.n14 vss.n5 17782.1
R338 vss.n20 vss.n3 17782.1
R339 vss.n18 vss.n4 17782.1
R340 vss.n18 vss.n3 17782.1
R341 vss.n13 vss.n12 1155.39
R342 vss.n13 vss.n7 1155.39
R343 vss.n12 vss.n10 1155.39
R344 vss.n10 vss.n7 1155.39
R345 vss.n21 vss.n2 1155.39
R346 vss.n21 vss.n1 1155.39
R347 vss.n17 vss.n2 1155.39
R348 vss.n17 vss.n1 1155.39
R349 vss.n16 vss.n15 321.536
R350 vss.n19 vss.n4 117.157
R351 vss.n9 vss.n8 117.157
R352 vss.t2 vss.n16 111.082
R353 vss.n15 vss.t0 111.082
R354 vss.n6 vss.t0 83.5719
R355 vss.n12 vss.n6 83.5719
R356 vss.n7 vss.n5 83.5719
R357 vss.t2 vss.n18 83.5719
R358 vss.n18 vss.n17 83.5719
R359 vss.n21 vss.n20 83.5719
R360 vss.n8 vss.n5 82.6335
R361 vss.n20 vss.n19 82.6335
R362 vss.n12 vss.n11 39.2368
R363 vss vss.n21 39.2368
R364 vss.n11 vss.t1 33.6974
R365 vss.n0 vss.t3 33.5437
R366 vss.n15 vss.n14 7.40556
R367 vss.n14 vss.n13 7.40556
R368 vss.n10 vss.n9 7.40556
R369 vss.n16 vss.n3 7.40556
R370 vss.n3 vss.n1 7.40556
R371 vss.n4 vss.n2 7.40556
R372 vss.n11 vss.n0 0.56685
R373 vss.n8 vss.t0 0.551604
R374 vss.n19 vss.t2 0.551604
R375 vss vss.n0 0.15419
C0 inp x1 68.6911f
C1 inn t1 66.5388f
C2 out x1 2.76309f
C3 vdd s1t 12.2155f
C4 out inp 0
C5 t1 x1 27.8849f
C6 t1 inp 68.1367f
C7 inn vdd 18.6531f
C8 out t1 29.545f
C9 s1t x1 0
C10 vdd x1 75.9923f
C11 s1t inp 0
C12 vdd inp 18.8642f
C13 out vdd 70.5292f
C14 inn x1 0.00128f
C15 t1 s1t 10.4861f
C16 inn inp 0.00291f
C17 t1 vdd 0.18072p
C18 out inn 70.8446f
C19 out vss 30.0272f
C20 inn vss 15.52188f
C21 x1 vss 54.55343f
C22 inp vss 16.69785f
C23 t1 vss 40.53842f
C24 s1t vss 5.86872f
C25 vdd vss 0.99895p
C26 vss.t3 vss 3.08505f
C27 vss.t1 vss 3.08812f
C28 vdd.t17 vss 9.34163f
C29 vdd.t18 vss 9.34163f
C30 vdd.t19 vss 9.34163f
C31 vdd.t20 vss 9.34163f
C32 vdd.t21 vss 9.34163f
C33 vdd.t22 vss 9.34163f
C34 vdd.t23 vss 9.34163f
C35 vdd.t24 vss 9.34163f
C36 vdd.t25 vss 9.34163f
C37 vdd.t26 vss 9.34163f
C38 vdd.t27 vss 9.34163f
C39 vdd.t28 vss 9.34163f
C40 vdd.t29 vss 9.34163f
C41 vdd.t30 vss 9.34163f
C42 vdd.t31 vss 9.34163f
C43 vdd.t32 vss 9.34163f
C44 vdd.t33 vss 9.34163f
C45 vdd.t0 vss 9.34163f
C46 vdd.t1 vss 9.34163f
C47 vdd.t2 vss 9.34163f
C48 vdd.t3 vss 9.34163f
C49 vdd.t4 vss 9.34163f
C50 vdd.t5 vss 9.34163f
C51 vdd.t6 vss 9.34163f
C52 vdd.t7 vss 9.34163f
C53 vdd.t8 vss 9.34163f
C54 vdd.t9 vss 9.34163f
C55 vdd.t10 vss 9.34163f
C56 vdd.t11 vss 9.34163f
C57 vdd.t12 vss 9.34163f
C58 vdd.t13 vss 9.34163f
C59 vdd.t14 vss 9.34163f
C60 vdd.t15 vss 9.34163f
C61 vdd.t16 vss 9.34834f
C62 vdd.n0 vss 1.74165f
C63 vdd.n1 vss 0.91134f
C64 vdd.n2 vss 0.91134f
C65 vdd.n3 vss 0.91134f
C66 vdd.n4 vss 0.91134f
C67 vdd.n5 vss 0.91134f
C68 vdd.n6 vss 0.91134f
C69 vdd.n7 vss 0.91134f
C70 vdd.n8 vss 0.91134f
C71 vdd.n9 vss 0.91134f
C72 vdd.n10 vss 0.91134f
C73 vdd.n11 vss 0.91134f
C74 vdd.n12 vss 0.91134f
C75 vdd.n13 vss 0.91134f
C76 vdd.n14 vss 0.91134f
C77 vdd.n15 vss 0.91134f
C78 vdd.n16 vss 0.91134f
C79 vdd.n17 vss 0.91134f
C80 vdd.n18 vss 0.91134f
C81 vdd.n19 vss 0.91134f
C82 vdd.n20 vss 0.91134f
C83 vdd.n21 vss 0.91134f
C84 vdd.n22 vss 0.91134f
C85 vdd.n23 vss 0.91134f
C86 vdd.n24 vss 0.91134f
C87 vdd.n25 vss 0.91134f
C88 vdd.n26 vss 0.91134f
C89 vdd.n27 vss 0.91134f
C90 vdd.n28 vss 0.91134f
C91 vdd.n29 vss 0.91134f
C92 vdd.n30 vss 0.91134f
C93 vdd.n31 vss 0.91134f
C94 vdd.n32 vss 0.89437f
C95 vdd.t39 vss 3.68123f
C96 vdd.n33 vss 0.46879f
C97 vdd.n34 vss 0.14709f
C98 vdd.n35 vss 0.14811f
C99 vdd.n36 vss 0.14811f
C100 vdd.n37 vss 0.14811f
C101 vdd.t38 vss 1.34612f
C102 vdd.n38 vss 1.34612f
C103 vdd.n39 vss 1.78108f
C104 vdd.n40 vss 1.78108f
C105 vdd.n41 vss 0.14709f
C106 vdd.n42 vss 0.49154f
C107 vdd.n43 vss 0.43288f
C108 vdd.t37 vss 3.67977f
C109 vdd.n44 vss 0.46879f
C110 vdd.n45 vss 0.14709f
C111 vdd.n46 vss 0.14811f
C112 vdd.n47 vss 0.14811f
C113 vdd.n48 vss 0.14811f
C114 vdd.t36 vss 1.34612f
C115 vdd.n49 vss 1.34612f
C116 vdd.n50 vss 1.78108f
C117 vdd.n51 vss 1.78108f
C118 vdd.n52 vss 0.14709f
C119 vdd.n53 vss 0.49154f
C120 vdd.n54 vss 0.43288f
C121 vdd.t35 vss 3.67977f
C122 vdd.n55 vss 0.46879f
C123 vdd.n56 vss 0.14709f
C124 vdd.n57 vss 0.14811f
C125 vdd.n58 vss 0.14811f
C126 vdd.n59 vss 0.14811f
C127 vdd.t34 vss 1.34612f
C128 vdd.n60 vss 1.34612f
C129 vdd.n61 vss 1.78108f
C130 vdd.n62 vss 1.78108f
C131 vdd.n63 vss 0.14709f
C132 vdd.n64 vss 0.49154f
C133 s1t.n0 vss 4.96164f
C134 t1.t19 vss 11.0442f
C135 t1.t18 vss 10.98372f
C136 t1.n0 vss 5.14567f
C137 t1.t17 vss 10.98372f
C138 t1.n1 vss 2.80283f
C139 t1.t16 vss 10.98372f
C140 t1.n2 vss 2.80283f
C141 t1.t15 vss 10.98372f
C142 t1.n3 vss 2.80283f
C143 t1.t14 vss 10.98372f
C144 t1.n4 vss 2.80283f
C145 t1.t13 vss 10.98372f
C146 t1.n5 vss 2.80283f
C147 t1.t12 vss 10.98372f
C148 t1.n6 vss 2.80283f
C149 t1.t11 vss 10.98372f
C150 t1.n7 vss 2.80283f
C151 t1.t10 vss 10.98372f
C152 t1.n8 vss 2.80283f
C153 t1.t9 vss 10.98372f
C154 t1.n9 vss 2.80283f
C155 t1.t8 vss 10.98372f
C156 t1.n10 vss 2.80283f
C157 t1.t7 vss 10.98372f
C158 t1.n11 vss 2.80283f
C159 t1.t6 vss 10.98372f
C160 t1.n12 vss 2.80283f
C161 t1.t5 vss 10.98372f
C162 t1.n13 vss 2.80283f
C163 t1.t4 vss 10.98372f
C164 t1.n14 vss 2.80283f
C165 t1.t3 vss 10.98372f
C166 t1.n15 vss 2.80283f
C167 t1.t36 vss 10.96921f
C168 t1.n16 vss 2.80283f
C169 t1.t35 vss 10.96803f
C170 t1.n17 vss 2.80283f
C171 t1.t34 vss 10.96803f
C172 t1.n18 vss 2.80283f
C173 t1.t33 vss 10.96803f
C174 t1.n19 vss 2.80283f
C175 t1.t32 vss 10.96803f
C176 t1.n20 vss 2.80283f
C177 t1.t31 vss 10.96803f
C178 t1.n21 vss 2.80283f
C179 t1.t30 vss 10.96803f
C180 t1.n22 vss 2.80283f
C181 t1.t29 vss 10.96803f
C182 t1.n23 vss 2.80283f
C183 t1.t28 vss 10.96803f
C184 t1.n24 vss 2.80283f
C185 t1.t27 vss 10.96803f
C186 t1.n25 vss 2.80283f
C187 t1.t26 vss 10.96803f
C188 t1.n26 vss 2.80283f
C189 t1.t25 vss 10.96803f
C190 t1.n27 vss 2.80283f
C191 t1.t24 vss 10.96803f
C192 t1.n28 vss 2.80283f
C193 t1.t23 vss 10.96803f
C194 t1.n29 vss 2.80283f
C195 t1.t22 vss 10.96803f
C196 t1.n30 vss 2.80283f
C197 t1.t21 vss 10.96803f
C198 t1.n31 vss 2.80283f
C199 t1.t20 vss 10.96803f
C200 t1.n32 vss 2.69147f
C201 t1.t0 vss 8.57119f
C202 t1.n33 vss 2.82223f
C203 t1.t2 vss 8.56973f
C204 t1.n34 vss 2.93359f
C205 t1.t1 vss 8.56973f
C206 inp.n0 vss 5.15416f
C207 inp.n1 vss 2.66736f
C208 inp.n2 vss 2.66736f
C209 inp.n3 vss 2.66736f
C210 inp.n4 vss 2.66736f
C211 inp.n5 vss 2.66736f
C212 inp.n6 vss 2.66736f
C213 inp.n7 vss 2.66736f
C214 inp.n8 vss 2.66736f
C215 inp.n9 vss 2.66736f
C216 inp.n10 vss 2.66736f
C217 inp.n11 vss 2.66736f
C218 inp.n12 vss 2.66736f
C219 inp.n13 vss 2.66736f
C220 inp.n14 vss 2.66736f
C221 x1.n0 vss 7.60353f
C222 x1.t18 vss 6.96477f
C223 x1.n1 vss 7.35686f
C224 x1.t13 vss 9.24101f
C225 x1.n2 vss 7.75509f
C226 x1.t3 vss 9.23984f
C227 x1.n3 vss 2.18585f
C228 x1.t6 vss 9.23984f
C229 x1.n4 vss 2.18585f
C230 x1.t9 vss 9.23984f
C231 x1.n5 vss 2.18585f
C232 x1.t2 vss 9.23984f
C233 x1.n6 vss 2.18585f
C234 x1.t10 vss 9.23984f
C235 x1.n7 vss 2.18585f
C236 x1.t16 vss 9.23984f
C237 x1.n8 vss 2.18585f
C238 x1.t0 vss 9.23984f
C239 x1.n9 vss 2.18585f
C240 x1.t8 vss 9.23984f
C241 x1.n10 vss 2.18585f
C242 x1.t1 vss 9.23984f
C243 x1.n11 vss 2.18585f
C244 x1.t12 vss 9.23984f
C245 x1.n12 vss 2.18585f
C246 x1.t4 vss 9.23984f
C247 x1.n13 vss 2.18585f
C248 x1.t5 vss 9.23984f
C249 x1.n14 vss 2.18585f
C250 x1.t14 vss 9.23984f
C251 x1.n15 vss 2.18585f
C252 x1.t7 vss 9.23984f
C253 x1.n16 vss 2.18585f
C254 x1.t11 vss 9.23984f
C255 x1.n17 vss 2.18585f
C256 x1.t15 vss 9.23984f
C257 inn.n0 vss 5.13134f
C258 inn.n1 vss 2.6564f
C259 inn.n2 vss 2.6564f
C260 inn.n3 vss 2.6564f
C261 inn.n4 vss 2.6564f
C262 inn.n5 vss 2.6564f
C263 inn.n6 vss 2.6564f
C264 inn.n7 vss 2.6564f
C265 inn.n8 vss 2.6564f
C266 inn.n9 vss 2.6564f
C267 inn.n10 vss 2.6564f
C268 inn.n11 vss 2.6564f
C269 inn.n12 vss 2.6564f
C270 inn.n13 vss 2.6564f
C271 inn.n14 vss 2.6564f
C272 out.t16 vss 7.82931f
C273 out.t8 vss 10.46557f
C274 out.n0 vss 5.32835f
C275 out.t6 vss 10.4644f
C276 out.n1 vss 2.60721f
C277 out.t11 vss 10.4644f
C278 out.n2 vss 2.60721f
C279 out.t5 vss 10.4644f
C280 out.n3 vss 2.60721f
C281 out.t13 vss 10.4644f
C282 out.n4 vss 2.60721f
C283 out.t10 vss 10.4644f
C284 out.n5 vss 2.60721f
C285 out.t12 vss 10.4644f
C286 out.n6 vss 2.60721f
C287 out.t7 vss 10.4644f
C288 out.n7 vss 2.60721f
C289 out.t17 vss 10.4644f
C290 out.n8 vss 2.60721f
C291 out.t15 vss 10.4644f
C292 out.n9 vss 2.60721f
C293 out.t9 vss 10.4644f
C294 out.n10 vss 2.60721f
C295 out.t1 vss 10.4644f
C296 out.n11 vss 2.60721f
C297 out.t3 vss 10.4644f
C298 out.n12 vss 2.60721f
C299 out.t0 vss 10.4644f
C300 out.n13 vss 2.60721f
C301 out.t14 vss 10.4644f
C302 out.n14 vss 2.60721f
C303 out.t4 vss 10.4644f
C304 out.n15 vss 2.60721f
C305 out.t2 vss 10.4644f
.ends
