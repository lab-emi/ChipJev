* NGSPICE file created from layout.ext - technology: sky130A

.subckt layout inn inp o1 out s1t s2a s2c s2cn s2cp t1 vdd vss x1
X0 t1.t0 s1t.t0 vss.t3 vss.t2 sky130_fd_pr__nfet_01v8 ad=1.8618 pd=13.42 as=1.8618 ps=13.42 w=6.42 l=0.15
X1 s2c.t1 o1.t3 vdd.t6 vdd.t5 sky130_fd_pr__pfet_01v8 ad=9.4134 pd=65.5 as=9.4134 ps=65.5 w=32.46 l=0.18
X2 x1.t1 inp.t0 t1.t2 vss.t1 sky130_fd_pr__nfet_01v8 ad=8.1345 pd=56.68 as=8.1345 ps=56.68 w=28.05 l=0.15
X3 s2a.t0 o1.t4 vss.t9 vss.t8 sky130_fd_pr__nfet_01v8 ad=0.1218 pd=1.42 as=0.1218 ps=1.42 w=0.42 l=0.18
X4 o1.t0 inn.t1 t1.t3 vss.t4 sky130_fd_pr__nfet_01v8 ad=8.1345 pd=56.68 as=8.1345 ps=56.68 w=28.05 l=0.15
X5 o1.t2 inn.t0 t1.t4 vss.t5 sky130_fd_pr__nfet_01v8 ad=8.1345 pd=56.68 as=8.1345 ps=56.68 w=28.05 l=0.15
X6 out.t0 s2cn.t1 s2a.t1 vss.t6 sky130_fd_pr__nfet_01v8 ad=12.9282 pd=89.74 as=12.9282 ps=89.74 w=44.58 l=0.18
X7 x1.t3 x1.t2 vdd.t1 vdd.t0 sky130_fd_pr__pfet_01v8 ad=1.2093 pd=8.92 as=1.2093 ps=8.92 w=4.17 l=0.15
X8 o1.t1 x1.t4 vdd.t3 vdd.t2 sky130_fd_pr__pfet_01v8 ad=1.2093 pd=8.92 as=1.2093 ps=8.92 w=4.17 l=0.15
X9 out.t2 s2cp.t0 s2c.t0 vdd.t4 sky130_fd_pr__pfet_01v8 ad=0.3393 pd=2.92 as=0.3393 ps=2.92 w=1.17 l=0.18
X10 x1.t0 inp.t1 t1.t1 vss.t0 sky130_fd_pr__nfet_01v8 ad=8.1345 pd=56.68 as=8.1345 ps=56.68 w=28.05 l=0.15
X11 out.t1 s2cn.t0 s2a.t2 vss.t7 sky130_fd_pr__nfet_01v8 ad=12.9282 pd=89.74 as=12.9282 ps=89.74 w=44.58 l=0.18
R0 s2c s2c.t0 256.401
R1 s2c s2c.t1 34.1281
R2 s2cp s2cp.t0 418.959
R3 out.n0 out.t2 255.536
R4 out out.t0 23.8873
R5 out.n0 out.t1 23.8873
R6 out out.n0 0.57766
R7 s2cn s2cn.t0 6198.27
R8 s2cn s2cn.t1 6197.7
R9 s2a s2a.t0 269.315
R10 s2a.n0 s2a.t2 25.426
R11 s2a.n0 s2a.t1 24.8488
R12 s2a s2a.n0 0.53348
R13 o1.n0 o1.t3 4592.72
R14 o1.n0 o1.t4 303.99
R15 o1.n1 o1.t1 87.6885
R16 o1 o1.t0 28.4982
R17 o1.n2 o1.t2 28.4982
R18 o1.n2 o1.n1 1.14918
R19 o1.n1 o1.n0 0.73135
R20 o1 o1.n2 0.57484
R21 inn inn.t0 4746.67
R22 inn inn.t1 4746.09
R23 x1.n0 x1.t4 941.639
R24 x1.n0 x1.t2 941.063
R25 x1.n1 x1.t3 92.4962
R26 x1 x1.t0 33.3059
R27 x1.n2 x1.t1 33.3059
R28 x1.n2 x1.n1 1.72352
R29 x1 x1.n2 0.57484
R30 x1.n1 x1.n0 0.15419
R31 inp inp.t0 4747.15
R32 inp inp.t1 4746.58
R33 t1 t1.t0 47.0312
R34 t1.n0 t1.t4 32.4379
R35 t1.n2 t1.t1 31.8636
R36 t1.n1 t1.t2 31.8636
R37 t1.n0 t1.t3 31.8636
R38 t1.n1 t1.n0 0.57484
R39 t1.n2 t1.n1 0.57484
R40 t1 t1.n2 0.53348
R41 s1t s1t.t0 1283.2
R42 vdd.n4 vdd.n1 12427.1
R43 vdd.n7 vdd.n3 12427.1
R44 vdd.n27 vdd.n24 2431.76
R45 vdd.n30 vdd.n26 2431.76
R46 vdd.n39 vdd.n36 2431.76
R47 vdd.n42 vdd.n38 2431.76
R48 vdd.n15 vdd.n12 1383.53
R49 vdd.n18 vdd.n14 1383.53
R50 vdd.n9 vdd.n8 1325.55
R51 vdd.n8 vdd.n2 1325.55
R52 vdd.n9 vdd.n0 1325.55
R53 vdd.n2 vdd.n0 1325.55
R54 vdd.n32 vdd.n31 259.389
R55 vdd.n31 vdd.n25 259.389
R56 vdd.n32 vdd.n23 259.389
R57 vdd.n25 vdd.n23 259.389
R58 vdd.n44 vdd.n43 259.389
R59 vdd.n43 vdd.n37 259.389
R60 vdd.n44 vdd.n35 259.389
R61 vdd.n37 vdd.n35 259.389
R62 vdd.n18 vdd.n17 227.891
R63 vdd.n16 vdd.n15 227.891
R64 vdd.n20 vdd.n19 147.577
R65 vdd.n19 vdd.n13 147.577
R66 vdd.n20 vdd.n11 147.577
R67 vdd.n13 vdd.n11 147.577
R68 vdd.n30 vdd.n29 126.13
R69 vdd.n28 vdd.n27 126.13
R70 vdd.n42 vdd.n41 126.13
R71 vdd.n40 vdd.n39 126.13
R72 vdd.n9 vdd.n1 92.5005
R73 vdd.n3 vdd.n2 92.5005
R74 vdd.n20 vdd.n12 92.5005
R75 vdd.n14 vdd.n13 92.5005
R76 vdd.n32 vdd.n24 92.5005
R77 vdd.n26 vdd.n25 92.5005
R78 vdd.n44 vdd.n36 92.5005
R79 vdd.n38 vdd.n37 92.5005
R80 vdd.n6 vdd.n1 91.6404
R81 vdd.n5 vdd.n3 91.6404
R82 vdd.n22 vdd.t3 91.5346
R83 vdd.n34 vdd.t1 91.5346
R84 vdd.n29 vdd.n24 84.4895
R85 vdd.n28 vdd.n26 84.4895
R86 vdd.n41 vdd.n36 84.4895
R87 vdd.n40 vdd.n38 84.4895
R88 vdd.n17 vdd.n12 72.4228
R89 vdd.n16 vdd.n14 72.4228
R90 vdd.n10 vdd.n9 39.424
R91 vdd.n21 vdd.n20 39.424
R92 vdd.n33 vdd.n32 39.4178
R93 vdd vdd.n44 39.4178
R94 vdd.n19 vdd.n18 37.0005
R95 vdd.n15 vdd.n11 37.0005
R96 vdd.n10 vdd.t6 35.5835
R97 vdd.n7 vdd.n6 23.979
R98 vdd.n5 vdd.n4 23.979
R99 vdd.t4 vdd.n16 15.2372
R100 vdd.n17 vdd.t4 15.2372
R101 vdd.n31 vdd.n30 13.2148
R102 vdd.n27 vdd.n23 13.2148
R103 vdd.n43 vdd.n42 13.2148
R104 vdd.n39 vdd.n35 13.2148
R105 vdd.t2 vdd.n28 4.79874
R106 vdd.n29 vdd.t2 4.79874
R107 vdd.t0 vdd.n40 4.79874
R108 vdd.n41 vdd.t0 4.79874
R109 vdd.n22 vdd.n21 2.15263
R110 vdd.n8 vdd.n7 1.90772
R111 vdd.n4 vdd.n0 1.90772
R112 vdd.n21 vdd.n10 0.57766
R113 vdd.n34 vdd.n33 0.42115
R114 vdd.t5 vdd.n5 0.179478
R115 vdd.n6 vdd.t5 0.179478
R116 vdd vdd.n34 0.15419
R117 vdd.n33 vdd.n22 0.15419
R118 vss.n36 vss.n35 27394.6
R119 vss.n40 vss.n35 27394.6
R120 vss.n40 vss.n34 27394.6
R121 vss.n56 vss.n25 27394.6
R122 vss.n56 vss.n24 27394.6
R123 vss.n42 vss.n25 27394.6
R124 vss.n42 vss.n24 27394.6
R125 vss.n63 vss.n21 17799.5
R126 vss.n63 vss.n20 17799.5
R127 vss.n59 vss.n21 17799.5
R128 vss.n59 vss.n20 17799.5
R129 vss.n73 vss.n18 17799.5
R130 vss.n67 vss.n18 17799.5
R131 vss.n73 vss.n17 17799.5
R132 vss.n67 vss.n17 17799.5
R133 vss.n79 vss.n11 17799.5
R134 vss.n79 vss.n10 17799.5
R135 vss.n70 vss.n11 17799.5
R136 vss.n70 vss.n10 17799.5
R137 vss.n90 vss.n6 17799.5
R138 vss.n86 vss.n6 17799.5
R139 vss.n90 vss.n5 17799.5
R140 vss.n86 vss.n5 17799.5
R141 vss.t6 vss.t7 8975.42
R142 vss.n45 vss.t6 7798.67
R143 vss.n93 vss.n3 5266.85
R144 vss.n83 vss.n4 5266.85
R145 vss.n83 vss.n3 5266.85
R146 vss.t6 vss.n44 4502.67
R147 vss.t0 vss.t1 4473.21
R148 vss.t4 vss.t5 4473.21
R149 vss.n91 vss.t0 3894.84
R150 vss.t4 vss.n72 3393.34
R151 vss.n58 vss.n57 1811.11
R152 vss.n49 vss.n31 1807.76
R153 vss.n47 vss.n32 1807.76
R154 vss.n47 vss.n31 1807.76
R155 vss.n39 vss.n28 1779.95
R156 vss.n39 vss.n38 1779.95
R157 vss.n37 vss.n28 1779.95
R158 vss.n38 vss.n37 1779.95
R159 vss.n55 vss.n54 1779.95
R160 vss.n55 vss.n26 1779.95
R161 vss.n54 vss.n27 1779.95
R162 vss.n27 vss.n26 1779.95
R163 vss.t8 vss.n45 1176.74
R164 vss.n62 vss.n61 1156.52
R165 vss.n62 vss.n22 1156.52
R166 vss.n61 vss.n60 1156.52
R167 vss.n60 vss.n22 1156.52
R168 vss.n74 vss.n16 1156.52
R169 vss.n66 vss.n16 1156.52
R170 vss.n74 vss.n15 1156.52
R171 vss.n66 vss.n15 1156.52
R172 vss.n78 vss.n77 1156.52
R173 vss.n78 vss.n12 1156.52
R174 vss.n77 vss.n13 1156.52
R175 vss.n13 vss.n12 1156.52
R176 vss.n89 vss.n88 1156.52
R177 vss.n88 vss.n87 1156.52
R178 vss.n89 vss.n7 1156.52
R179 vss.n87 vss.n7 1156.52
R180 vss.n72 vss.t1 1079.87
R181 vss.n48 vss.n32 714.225
R182 vss.n84 vss.n83 713.433
R183 vss.t2 vss.n91 578.37
R184 vss.n92 vss.n4 518.933
R185 vss.n81 vss.n80 358.425
R186 vss.n65 vss.n64 358.425
R187 vss.n94 vss.n2 342.212
R188 vss.n94 vss.n1 342.212
R189 vss.n82 vss.n2 342.212
R190 vss.n82 vss.n1 342.212
R191 vss.n72 vss.n69 304.226
R192 vss.n35 vss.t7 292.5
R193 vss.n35 vss.n28 292.5
R194 vss.n38 vss.n34 292.5
R195 vss.n24 vss.n23 292.5
R196 vss.n26 vss.n24 292.5
R197 vss.n86 vss.n85 292.5
R198 vss.n87 vss.n86 292.5
R199 vss.n83 vss.n82 292.5
R200 vss.n10 vss.n9 292.5
R201 vss.n12 vss.n10 292.5
R202 vss.n68 vss.n67 292.5
R203 vss.n67 vss.n66 292.5
R204 vss.n20 vss.n19 292.5
R205 vss.n22 vss.n20 292.5
R206 vss.t6 vss.n25 292.5
R207 vss.n54 vss.n25 292.5
R208 vss.t8 vss.n47 292.5
R209 vss.n47 vss.n46 292.5
R210 vss.n50 vss.n49 292.5
R211 vss.t0 vss.n90 292.5
R212 vss.n90 vss.n89 292.5
R213 vss.n94 vss.n93 292.5
R214 vss.n11 vss.t1 292.5
R215 vss.n77 vss.n11 292.5
R216 vss.n73 vss.t4 292.5
R217 vss.n74 vss.n73 292.5
R218 vss.n21 vss.t5 292.5
R219 vss.n61 vss.n21 292.5
R220 vss.n34 vss.n33 288.7
R221 vss.n52 vss.t9 272.2
R222 vss.n93 vss.n92 249.809
R223 vss.n45 vss.n31 195
R224 vss.n31 vss.n29 195
R225 vss.n32 vss.n30 195
R226 vss.n44 vss.n43 179.213
R227 vss.n44 vss.n41 179.213
R228 vss.n49 vss.n48 152.297
R229 vss.n50 vss.n30 117.46
R230 vss.n50 vss.n29 117.46
R231 vss.n46 vss.n30 117.46
R232 vss.n46 vss.n29 117.46
R233 vss.n48 vss.t8 115.564
R234 vss.n36 vss.n33 67.2084
R235 vss.n41 vss.n33 64.4122
R236 vss.n57 vss.n23 63.6941
R237 vss.n43 vss.n23 63.6941
R238 vss.n85 vss.n84 62.5072
R239 vss.n85 vss.n81 62.5072
R240 vss.n80 vss.n9 62.5072
R241 vss.n71 vss.n9 62.5072
R242 vss.n69 vss.n68 62.5072
R243 vss.n68 vss.n65 62.5072
R244 vss.n64 vss.n19 62.5072
R245 vss.n58 vss.n19 62.5072
R246 vss.n72 vss.n71 54.1994
R247 vss.n0 vss.t3 47.9928
R248 vss.n53 vss.n28 40.4819
R249 vss.n51 vss.n50 39.9048
R250 vss.n54 vss.n53 39.9048
R251 vss.n61 vss.n14 39.8985
R252 vss.n75 vss.n74 39.8985
R253 vss.n77 vss.n76 39.8985
R254 vss vss.n94 39.8985
R255 vss.n89 vss.n8 39.8985
R256 vss.n91 vss.n3 29.2505
R257 vss.n3 vss.n1 29.2505
R258 vss.n4 vss.n2 29.2505
R259 vss.n92 vss.t2 28.8204
R260 vss.n81 vss.n5 6.96479
R261 vss.n7 vss.n5 6.96479
R262 vss.n84 vss.n6 6.96479
R263 vss.n88 vss.n6 6.96479
R264 vss.n71 vss.n70 6.96479
R265 vss.n70 vss.n13 6.96479
R266 vss.n80 vss.n79 6.96479
R267 vss.n79 vss.n78 6.96479
R268 vss.n65 vss.n17 6.96479
R269 vss.n17 vss.n15 6.96479
R270 vss.n69 vss.n18 6.96479
R271 vss.n18 vss.n16 6.96479
R272 vss.n59 vss.n58 6.96479
R273 vss.n60 vss.n59 6.96479
R274 vss.n64 vss.n63 6.96479
R275 vss.n63 vss.n62 6.96479
R276 vss.n41 vss.n40 4.399
R277 vss.n40 vss.n39 4.399
R278 vss.n37 vss.n36 4.399
R279 vss.n43 vss.n42 4.399
R280 vss.n42 vss.n27 4.399
R281 vss.n57 vss.n56 4.399
R282 vss.n56 vss.n55 4.399
R283 vss.n51 vss.n14 1.72352
R284 vss.n76 vss.n8 0.57484
R285 vss.n76 vss.n75 0.57484
R286 vss.n75 vss.n14 0.57484
R287 vss.n53 vss.n52 0.42397
R288 vss.n8 vss.n0 0.42115
R289 vss vss.n0 0.15419
R290 vss.n52 vss.n51 0.15419
C0 s2cn s2c 0
C1 vdd s2c 7.65f
C2 o1 s2a 1.09905f
C3 vdd t1 0.04388f
C4 x1 vdd 5.14109f
C5 out s2cp 0.84116f
C6 out s2cn 1.94854f
C7 out vdd 0.39649f
C8 vdd inn 0.21895f
C9 s2a s2cp 0
C10 s2a s2cn 1.70332f
C11 s2a vdd 0.06731f
C12 o1 s2cp 0.08014f
C13 inp t1 0.91635f
C14 inp x1 1.6137f
C15 o1 s2cn 0.14834f
C16 o1 vdd 4.72718f
C17 inp inn 0.00283f
C18 s2cn s2cp 0
C19 vdd s2cp 0.83696f
C20 o1 inp 0
C21 vdd s2cn 0.21109f
C22 inp s1t 0
C23 out s2c 2.69755f
C24 x1 t1 9.84453f
C25 inn t1 0.88153f
C26 x1 inn 0
C27 s2a s2c 0
C28 o1 s2c 1.04539f
C29 s2a x1 0
C30 s2a out 10.596f
C31 o1 t1 8.97871f
C32 o1 x1 1.049f
C33 s1t t1 0.85698f
C34 x1 s1t 0
C35 o1 out 0.70092f
C36 o1 inn 1.71053f
C37 s2c s2cp 0.1632f
C38 s2c vss 9.08818f
C39 s2cp vss 3.78386f
C40 out vss 10.84811f
C41 s2cn vss 4.25343f
C42 s2a vss 15.19191f
C43 o1 vss 15.03441f
C44 inn vss 4.80998f
C45 x1 vss 16.87155f
C46 inp vss 5.03345f
C47 t1 vss 22.69009f
C48 s1t vss 3.29114f
C49 vdd vss 31.78809f
C50 vss.t3 vss 0.02939f
C51 vss.t9 vss 0.07139f
C52 vdd.t6 vss 1.91904f
C53 vdd.n0 vss 0.19571f
C54 vdd.n1 vss 0.19743f
C55 vdd.n2 vss 0.19743f
C56 vdd.n3 vss 0.19743f
C57 vdd.n4 vss 1.57431f
C58 vdd.t5 vss 2.04065f
C59 vdd.n7 vss 1.57431f
C60 vdd.n8 vss 0.19571f
C61 vdd.n9 vss 0.69841f
C62 vdd.n10 vss 1.35251f
C63 vdd.n11 vss 0.02256f
C64 vdd.n12 vss 0.02289f
C65 vdd.n13 vss 0.02289f
C66 vdd.n14 vss 0.02289f
C67 vdd.n15 vss 0.13719f
C68 vdd.t4 vss 0.19177f
C69 vdd.n18 vss 0.13719f
C70 vdd.n19 vss 0.02256f
C71 vdd.n20 vss 0.52388f
C72 vdd.n21 vss 1.03777f
C73 vdd.t3 vss 0.35529f
C74 vdd.n22 vss 1.26094f
C75 vdd.n23 vss 0.03871f
C76 vdd.n24 vss 0.03974f
C77 vdd.n25 vss 0.03974f
C78 vdd.n26 vss 0.03974f
C79 vdd.n27 vss 0.27317f
C80 vdd.t2 vss 0.35996f
C81 vdd.n30 vss 0.27317f
C82 vdd.n31 vss 0.03871f
C83 vdd.n32 vss 0.54031f
C84 vdd.n33 vss 0.66304f
C85 vdd.t1 vss 0.35459f
C86 vdd.n34 vss 0.95994f
C87 vdd.n35 vss 0.03871f
C88 vdd.n36 vss 0.03974f
C89 vdd.n37 vss 0.03974f
C90 vdd.n38 vss 0.03974f
C91 vdd.n39 vss 0.27317f
C92 vdd.t0 vss 0.35996f
C93 vdd.n42 vss 0.27317f
C94 vdd.n43 vss 0.03871f
C95 vdd.n44 vss 0.54031f
C96 t1.t4 vss 3.45136f
C97 t1.t3 vss 3.42839f
C98 t1.n0 vss 2.76003f
C99 t1.t2 vss 3.40579f
C100 t1.n1 vss 1.48934f
C101 t1.t1 vss 3.40574f
C102 t1.n2 vss 1.47399f
C103 t1.t0 vss 1.23798f
C104 x1.n0 vss 4.62003f
C105 x1.t3 vss 0.69646f
C106 x1.n1 vss 2.51591f
C107 x1.t1 vss 3.37848f
C108 x1.n2 vss 1.91386f
C109 x1.t0 vss 3.37843f
C110 o1.n0 vss 5.36513f
C111 o1.t1 vss 0.67593f
C112 o1.n1 vss 2.62066f
C113 o1.t2 vss 3.67644f
C114 o1.n2 vss 1.78736f
C115 o1.t0 vss 3.67638f
C116 s2a.t2 vss 4.98614f
C117 s2a.t1 vss 4.96201f
C118 s2a.n0 vss 2.27433f
C119 s2a.t0 vss 0.20496f
C120 out.t2 vss 0.27292f
C121 out.t1 vss 6.20288f
C122 out.n0 vss 4.15114f
C123 out.t0 vss 6.20283f
C124 s2c.t1 vss 5.66969f
C125 s2c.t0 vss 0.34697f
.ends
